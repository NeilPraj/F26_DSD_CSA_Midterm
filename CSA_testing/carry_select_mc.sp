* carry_select_16 Monte Carlo testbench
* GENERATED by gen_mc.py -- edit the script, not this file.
.include ../cell_lib.sp

.global vdd
.global vss
Vdd vdd 0 dc 3.3v
Vss vss 0 dc 0

* Worst case: A = 0xFFFF, CIN = 0, B toggles 0x0000 <-> 0x0001 (only B0 switches)
* B=0x0000 -> S=0xFFFF, COUT=0
* B=0x0001 -> S=0x0000, COUT=1
* The carry generated at bit 0 ripples through stage 1's full adders (fa0_0 -> fa1_0),
* then through every carry-select mux (c2 -> c5 -> c9 -> cE -> cout). Toggling CIN instead
* would skip the stage-1 ripple, since CIN drives the first mux select directly.
xdut vdd vdd vdd vdd vdd vdd vdd vdd vdd vdd vdd vdd vdd vdd vdd vdd b0 vss vss vss vss vss vss vss vss vss vss vss vss vss vss vss cin s0 s1 s2 s3 s4 s5 s6 s7 s8 s9 sa sb sc sd se sf cout carry_select_16
Cs0 s0 vss 10f
Cs1 s1 vss 10f
Cs2 s2 vss 10f
Cs3 s3 vss 10f
Cs4 s4 vss 10f
Cs5 s5 vss 10f
Cs6 s6 vss 10f
Cs7 s7 vss 10f
Cs8 s8 vss 10f
Cs9 s9 vss 10f
Csa sa vss 10f
Csb sb vss 10f
Csc sc vss 10f
Csd sd vss 10f
Cse se vss 10f
Csf sf vss 10f
Ccout cout vss 10f
Vcin cin 0 dc 0
Vb0  b0  0 PULSE(0v 3.3v 50n 1n 1n 49n 100n)

.control
let mc_runs = 100
let current_run = 0
set curplot = new
set tran_meas = $curplot
let tplh_cout = vector(mc_runs)
let tphl_cout = vector(mc_runs)
let tplh_sf   = vector(mc_runs)
let tphl_sf   = vector(mc_runs)

define agauss(nom, avar, sig) (nom + avar/sig * sgauss(0))

* nominal sizes, read once from reference instances
let xor_m0w = @m.xdut.xfa0_0.xxor1.m0[w]
let xor_m0l = @m.xdut.xfa0_0.xxor1.m0[l]
let xor_m1w = @m.xdut.xfa0_0.xxor1.m1[w]
let xor_m1l = @m.xdut.xfa0_0.xxor1.m1[l]
let xor_m2w = @m.xdut.xfa0_0.xxor1.m2[w]
let xor_m2l = @m.xdut.xfa0_0.xxor1.m2[l]
let xor_m3w = @m.xdut.xfa0_0.xxor1.m3[w]
let xor_m3l = @m.xdut.xfa0_0.xxor1.m3[l]
let xor_m4w = @m.xdut.xfa0_0.xxor1.m4[w]
let xor_m4l = @m.xdut.xfa0_0.xxor1.m4[l]
let xor_m5w = @m.xdut.xfa0_0.xxor1.m5[w]
let xor_m5l = @m.xdut.xfa0_0.xxor1.m5[l]
let xor_m6w = @m.xdut.xfa0_0.xxor1.m6[w]
let xor_m6l = @m.xdut.xfa0_0.xxor1.m6[l]
let xor_m7w = @m.xdut.xfa0_0.xxor1.m7[w]
let xor_m7l = @m.xdut.xfa0_0.xxor1.m7[l]
let xor_m8w = @m.xdut.xfa0_0.xxor1.m8[w]
let xor_m8l = @m.xdut.xfa0_0.xxor1.m8[l]
let xor_m9w = @m.xdut.xfa0_0.xxor1.m9[w]
let xor_m9l = @m.xdut.xfa0_0.xxor1.m9[l]
let mux_mo0w = @m.xdut.xfa0_0.xmux1.mo0[w]
let mux_mo0l = @m.xdut.xfa0_0.xmux1.mo0[l]
let mux_mo1w = @m.xdut.xfa0_0.xmux1.mo1[w]
let mux_mo1l = @m.xdut.xfa0_0.xmux1.mo1[l]
let mux_m0w = @m.xdut.xfa0_0.xmux1.m0[w]
let mux_m0l = @m.xdut.xfa0_0.xmux1.m0[l]
let mux_m1w = @m.xdut.xfa0_0.xmux1.m1[w]
let mux_m1l = @m.xdut.xfa0_0.xmux1.m1[l]
let mux_m2w = @m.xdut.xfa0_0.xmux1.m2[w]
let mux_m2l = @m.xdut.xfa0_0.xmux1.m2[l]
let mux_m3w = @m.xdut.xfa0_0.xmux1.m3[w]
let mux_m3l = @m.xdut.xfa0_0.xmux1.m3[l]
let mux_m4w = @m.xdut.xfa0_0.xmux1.m4[w]
let mux_m4l = @m.xdut.xfa0_0.xmux1.m4[l]
let mux_m5w = @m.xdut.xfa0_0.xmux1.m5[w]
let mux_m5l = @m.xdut.xfa0_0.xmux1.m5[l]
let mux_m6w = @m.xdut.xfa0_0.xmux1.m6[w]
let mux_m6l = @m.xdut.xfa0_0.xmux1.m6[l]
let mux_m7w = @m.xdut.xfa0_0.xmux1.m7[w]
let mux_m7l = @m.xdut.xfa0_0.xmux1.m7[l]
let mux_m8w = @m.xdut.xfa0_0.xmux1.m8[w]
let mux_m8l = @m.xdut.xfa0_0.xmux1.m8[l]
let mux_m9w = @m.xdut.xfa0_0.xmux1.m9[w]
let mux_m9l = @m.xdut.xfa0_0.xmux1.m9[l]

dowhile current_run < mc_runs
  alter @m.xdut.xfa0_0.xxor1.m0[w] = agauss(xor_m0w, 18n, 3)
  alter @m.xdut.xfa0_0.xxor1.m0[l] = agauss(xor_m0l, 18n, 3)
  alter @m.xdut.xfa0_0.xxor1.m1[w] = agauss(xor_m1w, 18n, 3)
  alter @m.xdut.xfa0_0.xxor1.m1[l] = agauss(xor_m1l, 18n, 3)
  alter @m.xdut.xfa0_0.xxor1.m2[w] = agauss(xor_m2w, 18n, 3)
  alter @m.xdut.xfa0_0.xxor1.m2[l] = agauss(xor_m2l, 18n, 3)
  alter @m.xdut.xfa0_0.xxor1.m3[w] = agauss(xor_m3w, 18n, 3)
  alter @m.xdut.xfa0_0.xxor1.m3[l] = agauss(xor_m3l, 18n, 3)
  alter @m.xdut.xfa0_0.xxor1.m4[w] = agauss(xor_m4w, 18n, 3)
  alter @m.xdut.xfa0_0.xxor1.m4[l] = agauss(xor_m4l, 18n, 3)
  alter @m.xdut.xfa0_0.xxor1.m5[w] = agauss(xor_m5w, 18n, 3)
  alter @m.xdut.xfa0_0.xxor1.m5[l] = agauss(xor_m5l, 18n, 3)
  alter @m.xdut.xfa0_0.xxor1.m6[w] = agauss(xor_m6w, 18n, 3)
  alter @m.xdut.xfa0_0.xxor1.m6[l] = agauss(xor_m6l, 18n, 3)
  alter @m.xdut.xfa0_0.xxor1.m7[w] = agauss(xor_m7w, 18n, 3)
  alter @m.xdut.xfa0_0.xxor1.m7[l] = agauss(xor_m7l, 18n, 3)
  alter @m.xdut.xfa0_0.xxor1.m8[w] = agauss(xor_m8w, 18n, 3)
  alter @m.xdut.xfa0_0.xxor1.m8[l] = agauss(xor_m8l, 18n, 3)
  alter @m.xdut.xfa0_0.xxor1.m9[w] = agauss(xor_m9w, 18n, 3)
  alter @m.xdut.xfa0_0.xxor1.m9[l] = agauss(xor_m9l, 18n, 3)
  alter @m.xdut.xfa0_0.xxor2.m0[w] = agauss(xor_m0w, 18n, 3)
  alter @m.xdut.xfa0_0.xxor2.m0[l] = agauss(xor_m0l, 18n, 3)
  alter @m.xdut.xfa0_0.xxor2.m1[w] = agauss(xor_m1w, 18n, 3)
  alter @m.xdut.xfa0_0.xxor2.m1[l] = agauss(xor_m1l, 18n, 3)
  alter @m.xdut.xfa0_0.xxor2.m2[w] = agauss(xor_m2w, 18n, 3)
  alter @m.xdut.xfa0_0.xxor2.m2[l] = agauss(xor_m2l, 18n, 3)
  alter @m.xdut.xfa0_0.xxor2.m3[w] = agauss(xor_m3w, 18n, 3)
  alter @m.xdut.xfa0_0.xxor2.m3[l] = agauss(xor_m3l, 18n, 3)
  alter @m.xdut.xfa0_0.xxor2.m4[w] = agauss(xor_m4w, 18n, 3)
  alter @m.xdut.xfa0_0.xxor2.m4[l] = agauss(xor_m4l, 18n, 3)
  alter @m.xdut.xfa0_0.xxor2.m5[w] = agauss(xor_m5w, 18n, 3)
  alter @m.xdut.xfa0_0.xxor2.m5[l] = agauss(xor_m5l, 18n, 3)
  alter @m.xdut.xfa0_0.xxor2.m6[w] = agauss(xor_m6w, 18n, 3)
  alter @m.xdut.xfa0_0.xxor2.m6[l] = agauss(xor_m6l, 18n, 3)
  alter @m.xdut.xfa0_0.xxor2.m7[w] = agauss(xor_m7w, 18n, 3)
  alter @m.xdut.xfa0_0.xxor2.m7[l] = agauss(xor_m7l, 18n, 3)
  alter @m.xdut.xfa0_0.xxor2.m8[w] = agauss(xor_m8w, 18n, 3)
  alter @m.xdut.xfa0_0.xxor2.m8[l] = agauss(xor_m8l, 18n, 3)
  alter @m.xdut.xfa0_0.xxor2.m9[w] = agauss(xor_m9w, 18n, 3)
  alter @m.xdut.xfa0_0.xxor2.m9[l] = agauss(xor_m9l, 18n, 3)
  alter @m.xdut.xfa0_0.xmux1.mo0[w] = agauss(mux_mo0w, 18n, 3)
  alter @m.xdut.xfa0_0.xmux1.mo0[l] = agauss(mux_mo0l, 18n, 3)
  alter @m.xdut.xfa0_0.xmux1.mo1[w] = agauss(mux_mo1w, 18n, 3)
  alter @m.xdut.xfa0_0.xmux1.mo1[l] = agauss(mux_mo1l, 18n, 3)
  alter @m.xdut.xfa0_0.xmux1.m0[w] = agauss(mux_m0w, 18n, 3)
  alter @m.xdut.xfa0_0.xmux1.m0[l] = agauss(mux_m0l, 18n, 3)
  alter @m.xdut.xfa0_0.xmux1.m1[w] = agauss(mux_m1w, 18n, 3)
  alter @m.xdut.xfa0_0.xmux1.m1[l] = agauss(mux_m1l, 18n, 3)
  alter @m.xdut.xfa0_0.xmux1.m2[w] = agauss(mux_m2w, 18n, 3)
  alter @m.xdut.xfa0_0.xmux1.m2[l] = agauss(mux_m2l, 18n, 3)
  alter @m.xdut.xfa0_0.xmux1.m3[w] = agauss(mux_m3w, 18n, 3)
  alter @m.xdut.xfa0_0.xmux1.m3[l] = agauss(mux_m3l, 18n, 3)
  alter @m.xdut.xfa0_0.xmux1.m4[w] = agauss(mux_m4w, 18n, 3)
  alter @m.xdut.xfa0_0.xmux1.m4[l] = agauss(mux_m4l, 18n, 3)
  alter @m.xdut.xfa0_0.xmux1.m5[w] = agauss(mux_m5w, 18n, 3)
  alter @m.xdut.xfa0_0.xmux1.m5[l] = agauss(mux_m5l, 18n, 3)
  alter @m.xdut.xfa0_0.xmux1.m6[w] = agauss(mux_m6w, 18n, 3)
  alter @m.xdut.xfa0_0.xmux1.m6[l] = agauss(mux_m6l, 18n, 3)
  alter @m.xdut.xfa0_0.xmux1.m7[w] = agauss(mux_m7w, 18n, 3)
  alter @m.xdut.xfa0_0.xmux1.m7[l] = agauss(mux_m7l, 18n, 3)
  alter @m.xdut.xfa0_0.xmux1.m8[w] = agauss(mux_m8w, 18n, 3)
  alter @m.xdut.xfa0_0.xmux1.m8[l] = agauss(mux_m8l, 18n, 3)
  alter @m.xdut.xfa0_0.xmux1.m9[w] = agauss(mux_m9w, 18n, 3)
  alter @m.xdut.xfa0_0.xmux1.m9[l] = agauss(mux_m9l, 18n, 3)
  alter @m.xdut.xfa0_1.xxor1.m0[w] = agauss(xor_m0w, 18n, 3)
  alter @m.xdut.xfa0_1.xxor1.m0[l] = agauss(xor_m0l, 18n, 3)
  alter @m.xdut.xfa0_1.xxor1.m1[w] = agauss(xor_m1w, 18n, 3)
  alter @m.xdut.xfa0_1.xxor1.m1[l] = agauss(xor_m1l, 18n, 3)
  alter @m.xdut.xfa0_1.xxor1.m2[w] = agauss(xor_m2w, 18n, 3)
  alter @m.xdut.xfa0_1.xxor1.m2[l] = agauss(xor_m2l, 18n, 3)
  alter @m.xdut.xfa0_1.xxor1.m3[w] = agauss(xor_m3w, 18n, 3)
  alter @m.xdut.xfa0_1.xxor1.m3[l] = agauss(xor_m3l, 18n, 3)
  alter @m.xdut.xfa0_1.xxor1.m4[w] = agauss(xor_m4w, 18n, 3)
  alter @m.xdut.xfa0_1.xxor1.m4[l] = agauss(xor_m4l, 18n, 3)
  alter @m.xdut.xfa0_1.xxor1.m5[w] = agauss(xor_m5w, 18n, 3)
  alter @m.xdut.xfa0_1.xxor1.m5[l] = agauss(xor_m5l, 18n, 3)
  alter @m.xdut.xfa0_1.xxor1.m6[w] = agauss(xor_m6w, 18n, 3)
  alter @m.xdut.xfa0_1.xxor1.m6[l] = agauss(xor_m6l, 18n, 3)
  alter @m.xdut.xfa0_1.xxor1.m7[w] = agauss(xor_m7w, 18n, 3)
  alter @m.xdut.xfa0_1.xxor1.m7[l] = agauss(xor_m7l, 18n, 3)
  alter @m.xdut.xfa0_1.xxor1.m8[w] = agauss(xor_m8w, 18n, 3)
  alter @m.xdut.xfa0_1.xxor1.m8[l] = agauss(xor_m8l, 18n, 3)
  alter @m.xdut.xfa0_1.xxor1.m9[w] = agauss(xor_m9w, 18n, 3)
  alter @m.xdut.xfa0_1.xxor1.m9[l] = agauss(xor_m9l, 18n, 3)
  alter @m.xdut.xfa0_1.xxor2.m0[w] = agauss(xor_m0w, 18n, 3)
  alter @m.xdut.xfa0_1.xxor2.m0[l] = agauss(xor_m0l, 18n, 3)
  alter @m.xdut.xfa0_1.xxor2.m1[w] = agauss(xor_m1w, 18n, 3)
  alter @m.xdut.xfa0_1.xxor2.m1[l] = agauss(xor_m1l, 18n, 3)
  alter @m.xdut.xfa0_1.xxor2.m2[w] = agauss(xor_m2w, 18n, 3)
  alter @m.xdut.xfa0_1.xxor2.m2[l] = agauss(xor_m2l, 18n, 3)
  alter @m.xdut.xfa0_1.xxor2.m3[w] = agauss(xor_m3w, 18n, 3)
  alter @m.xdut.xfa0_1.xxor2.m3[l] = agauss(xor_m3l, 18n, 3)
  alter @m.xdut.xfa0_1.xxor2.m4[w] = agauss(xor_m4w, 18n, 3)
  alter @m.xdut.xfa0_1.xxor2.m4[l] = agauss(xor_m4l, 18n, 3)
  alter @m.xdut.xfa0_1.xxor2.m5[w] = agauss(xor_m5w, 18n, 3)
  alter @m.xdut.xfa0_1.xxor2.m5[l] = agauss(xor_m5l, 18n, 3)
  alter @m.xdut.xfa0_1.xxor2.m6[w] = agauss(xor_m6w, 18n, 3)
  alter @m.xdut.xfa0_1.xxor2.m6[l] = agauss(xor_m6l, 18n, 3)
  alter @m.xdut.xfa0_1.xxor2.m7[w] = agauss(xor_m7w, 18n, 3)
  alter @m.xdut.xfa0_1.xxor2.m7[l] = agauss(xor_m7l, 18n, 3)
  alter @m.xdut.xfa0_1.xxor2.m8[w] = agauss(xor_m8w, 18n, 3)
  alter @m.xdut.xfa0_1.xxor2.m8[l] = agauss(xor_m8l, 18n, 3)
  alter @m.xdut.xfa0_1.xxor2.m9[w] = agauss(xor_m9w, 18n, 3)
  alter @m.xdut.xfa0_1.xxor2.m9[l] = agauss(xor_m9l, 18n, 3)
  alter @m.xdut.xfa0_1.xmux1.mo0[w] = agauss(mux_mo0w, 18n, 3)
  alter @m.xdut.xfa0_1.xmux1.mo0[l] = agauss(mux_mo0l, 18n, 3)
  alter @m.xdut.xfa0_1.xmux1.mo1[w] = agauss(mux_mo1w, 18n, 3)
  alter @m.xdut.xfa0_1.xmux1.mo1[l] = agauss(mux_mo1l, 18n, 3)
  alter @m.xdut.xfa0_1.xmux1.m0[w] = agauss(mux_m0w, 18n, 3)
  alter @m.xdut.xfa0_1.xmux1.m0[l] = agauss(mux_m0l, 18n, 3)
  alter @m.xdut.xfa0_1.xmux1.m1[w] = agauss(mux_m1w, 18n, 3)
  alter @m.xdut.xfa0_1.xmux1.m1[l] = agauss(mux_m1l, 18n, 3)
  alter @m.xdut.xfa0_1.xmux1.m2[w] = agauss(mux_m2w, 18n, 3)
  alter @m.xdut.xfa0_1.xmux1.m2[l] = agauss(mux_m2l, 18n, 3)
  alter @m.xdut.xfa0_1.xmux1.m3[w] = agauss(mux_m3w, 18n, 3)
  alter @m.xdut.xfa0_1.xmux1.m3[l] = agauss(mux_m3l, 18n, 3)
  alter @m.xdut.xfa0_1.xmux1.m4[w] = agauss(mux_m4w, 18n, 3)
  alter @m.xdut.xfa0_1.xmux1.m4[l] = agauss(mux_m4l, 18n, 3)
  alter @m.xdut.xfa0_1.xmux1.m5[w] = agauss(mux_m5w, 18n, 3)
  alter @m.xdut.xfa0_1.xmux1.m5[l] = agauss(mux_m5l, 18n, 3)
  alter @m.xdut.xfa0_1.xmux1.m6[w] = agauss(mux_m6w, 18n, 3)
  alter @m.xdut.xfa0_1.xmux1.m6[l] = agauss(mux_m6l, 18n, 3)
  alter @m.xdut.xfa0_1.xmux1.m7[w] = agauss(mux_m7w, 18n, 3)
  alter @m.xdut.xfa0_1.xmux1.m7[l] = agauss(mux_m7l, 18n, 3)
  alter @m.xdut.xfa0_1.xmux1.m8[w] = agauss(mux_m8w, 18n, 3)
  alter @m.xdut.xfa0_1.xmux1.m8[l] = agauss(mux_m8l, 18n, 3)
  alter @m.xdut.xfa0_1.xmux1.m9[w] = agauss(mux_m9w, 18n, 3)
  alter @m.xdut.xfa0_1.xmux1.m9[l] = agauss(mux_m9l, 18n, 3)
  alter @m.xdut.xfa1_0.xxor1.m0[w] = agauss(xor_m0w, 18n, 3)
  alter @m.xdut.xfa1_0.xxor1.m0[l] = agauss(xor_m0l, 18n, 3)
  alter @m.xdut.xfa1_0.xxor1.m1[w] = agauss(xor_m1w, 18n, 3)
  alter @m.xdut.xfa1_0.xxor1.m1[l] = agauss(xor_m1l, 18n, 3)
  alter @m.xdut.xfa1_0.xxor1.m2[w] = agauss(xor_m2w, 18n, 3)
  alter @m.xdut.xfa1_0.xxor1.m2[l] = agauss(xor_m2l, 18n, 3)
  alter @m.xdut.xfa1_0.xxor1.m3[w] = agauss(xor_m3w, 18n, 3)
  alter @m.xdut.xfa1_0.xxor1.m3[l] = agauss(xor_m3l, 18n, 3)
  alter @m.xdut.xfa1_0.xxor1.m4[w] = agauss(xor_m4w, 18n, 3)
  alter @m.xdut.xfa1_0.xxor1.m4[l] = agauss(xor_m4l, 18n, 3)
  alter @m.xdut.xfa1_0.xxor1.m5[w] = agauss(xor_m5w, 18n, 3)
  alter @m.xdut.xfa1_0.xxor1.m5[l] = agauss(xor_m5l, 18n, 3)
  alter @m.xdut.xfa1_0.xxor1.m6[w] = agauss(xor_m6w, 18n, 3)
  alter @m.xdut.xfa1_0.xxor1.m6[l] = agauss(xor_m6l, 18n, 3)
  alter @m.xdut.xfa1_0.xxor1.m7[w] = agauss(xor_m7w, 18n, 3)
  alter @m.xdut.xfa1_0.xxor1.m7[l] = agauss(xor_m7l, 18n, 3)
  alter @m.xdut.xfa1_0.xxor1.m8[w] = agauss(xor_m8w, 18n, 3)
  alter @m.xdut.xfa1_0.xxor1.m8[l] = agauss(xor_m8l, 18n, 3)
  alter @m.xdut.xfa1_0.xxor1.m9[w] = agauss(xor_m9w, 18n, 3)
  alter @m.xdut.xfa1_0.xxor1.m9[l] = agauss(xor_m9l, 18n, 3)
  alter @m.xdut.xfa1_0.xxor2.m0[w] = agauss(xor_m0w, 18n, 3)
  alter @m.xdut.xfa1_0.xxor2.m0[l] = agauss(xor_m0l, 18n, 3)
  alter @m.xdut.xfa1_0.xxor2.m1[w] = agauss(xor_m1w, 18n, 3)
  alter @m.xdut.xfa1_0.xxor2.m1[l] = agauss(xor_m1l, 18n, 3)
  alter @m.xdut.xfa1_0.xxor2.m2[w] = agauss(xor_m2w, 18n, 3)
  alter @m.xdut.xfa1_0.xxor2.m2[l] = agauss(xor_m2l, 18n, 3)
  alter @m.xdut.xfa1_0.xxor2.m3[w] = agauss(xor_m3w, 18n, 3)
  alter @m.xdut.xfa1_0.xxor2.m3[l] = agauss(xor_m3l, 18n, 3)
  alter @m.xdut.xfa1_0.xxor2.m4[w] = agauss(xor_m4w, 18n, 3)
  alter @m.xdut.xfa1_0.xxor2.m4[l] = agauss(xor_m4l, 18n, 3)
  alter @m.xdut.xfa1_0.xxor2.m5[w] = agauss(xor_m5w, 18n, 3)
  alter @m.xdut.xfa1_0.xxor2.m5[l] = agauss(xor_m5l, 18n, 3)
  alter @m.xdut.xfa1_0.xxor2.m6[w] = agauss(xor_m6w, 18n, 3)
  alter @m.xdut.xfa1_0.xxor2.m6[l] = agauss(xor_m6l, 18n, 3)
  alter @m.xdut.xfa1_0.xxor2.m7[w] = agauss(xor_m7w, 18n, 3)
  alter @m.xdut.xfa1_0.xxor2.m7[l] = agauss(xor_m7l, 18n, 3)
  alter @m.xdut.xfa1_0.xxor2.m8[w] = agauss(xor_m8w, 18n, 3)
  alter @m.xdut.xfa1_0.xxor2.m8[l] = agauss(xor_m8l, 18n, 3)
  alter @m.xdut.xfa1_0.xxor2.m9[w] = agauss(xor_m9w, 18n, 3)
  alter @m.xdut.xfa1_0.xxor2.m9[l] = agauss(xor_m9l, 18n, 3)
  alter @m.xdut.xfa1_0.xmux1.mo0[w] = agauss(mux_mo0w, 18n, 3)
  alter @m.xdut.xfa1_0.xmux1.mo0[l] = agauss(mux_mo0l, 18n, 3)
  alter @m.xdut.xfa1_0.xmux1.mo1[w] = agauss(mux_mo1w, 18n, 3)
  alter @m.xdut.xfa1_0.xmux1.mo1[l] = agauss(mux_mo1l, 18n, 3)
  alter @m.xdut.xfa1_0.xmux1.m0[w] = agauss(mux_m0w, 18n, 3)
  alter @m.xdut.xfa1_0.xmux1.m0[l] = agauss(mux_m0l, 18n, 3)
  alter @m.xdut.xfa1_0.xmux1.m1[w] = agauss(mux_m1w, 18n, 3)
  alter @m.xdut.xfa1_0.xmux1.m1[l] = agauss(mux_m1l, 18n, 3)
  alter @m.xdut.xfa1_0.xmux1.m2[w] = agauss(mux_m2w, 18n, 3)
  alter @m.xdut.xfa1_0.xmux1.m2[l] = agauss(mux_m2l, 18n, 3)
  alter @m.xdut.xfa1_0.xmux1.m3[w] = agauss(mux_m3w, 18n, 3)
  alter @m.xdut.xfa1_0.xmux1.m3[l] = agauss(mux_m3l, 18n, 3)
  alter @m.xdut.xfa1_0.xmux1.m4[w] = agauss(mux_m4w, 18n, 3)
  alter @m.xdut.xfa1_0.xmux1.m4[l] = agauss(mux_m4l, 18n, 3)
  alter @m.xdut.xfa1_0.xmux1.m5[w] = agauss(mux_m5w, 18n, 3)
  alter @m.xdut.xfa1_0.xmux1.m5[l] = agauss(mux_m5l, 18n, 3)
  alter @m.xdut.xfa1_0.xmux1.m6[w] = agauss(mux_m6w, 18n, 3)
  alter @m.xdut.xfa1_0.xmux1.m6[l] = agauss(mux_m6l, 18n, 3)
  alter @m.xdut.xfa1_0.xmux1.m7[w] = agauss(mux_m7w, 18n, 3)
  alter @m.xdut.xfa1_0.xmux1.m7[l] = agauss(mux_m7l, 18n, 3)
  alter @m.xdut.xfa1_0.xmux1.m8[w] = agauss(mux_m8w, 18n, 3)
  alter @m.xdut.xfa1_0.xmux1.m8[l] = agauss(mux_m8l, 18n, 3)
  alter @m.xdut.xfa1_0.xmux1.m9[w] = agauss(mux_m9w, 18n, 3)
  alter @m.xdut.xfa1_0.xmux1.m9[l] = agauss(mux_m9l, 18n, 3)
  alter @m.xdut.xfa1_1.xxor1.m0[w] = agauss(xor_m0w, 18n, 3)
  alter @m.xdut.xfa1_1.xxor1.m0[l] = agauss(xor_m0l, 18n, 3)
  alter @m.xdut.xfa1_1.xxor1.m1[w] = agauss(xor_m1w, 18n, 3)
  alter @m.xdut.xfa1_1.xxor1.m1[l] = agauss(xor_m1l, 18n, 3)
  alter @m.xdut.xfa1_1.xxor1.m2[w] = agauss(xor_m2w, 18n, 3)
  alter @m.xdut.xfa1_1.xxor1.m2[l] = agauss(xor_m2l, 18n, 3)
  alter @m.xdut.xfa1_1.xxor1.m3[w] = agauss(xor_m3w, 18n, 3)
  alter @m.xdut.xfa1_1.xxor1.m3[l] = agauss(xor_m3l, 18n, 3)
  alter @m.xdut.xfa1_1.xxor1.m4[w] = agauss(xor_m4w, 18n, 3)
  alter @m.xdut.xfa1_1.xxor1.m4[l] = agauss(xor_m4l, 18n, 3)
  alter @m.xdut.xfa1_1.xxor1.m5[w] = agauss(xor_m5w, 18n, 3)
  alter @m.xdut.xfa1_1.xxor1.m5[l] = agauss(xor_m5l, 18n, 3)
  alter @m.xdut.xfa1_1.xxor1.m6[w] = agauss(xor_m6w, 18n, 3)
  alter @m.xdut.xfa1_1.xxor1.m6[l] = agauss(xor_m6l, 18n, 3)
  alter @m.xdut.xfa1_1.xxor1.m7[w] = agauss(xor_m7w, 18n, 3)
  alter @m.xdut.xfa1_1.xxor1.m7[l] = agauss(xor_m7l, 18n, 3)
  alter @m.xdut.xfa1_1.xxor1.m8[w] = agauss(xor_m8w, 18n, 3)
  alter @m.xdut.xfa1_1.xxor1.m8[l] = agauss(xor_m8l, 18n, 3)
  alter @m.xdut.xfa1_1.xxor1.m9[w] = agauss(xor_m9w, 18n, 3)
  alter @m.xdut.xfa1_1.xxor1.m9[l] = agauss(xor_m9l, 18n, 3)
  alter @m.xdut.xfa1_1.xxor2.m0[w] = agauss(xor_m0w, 18n, 3)
  alter @m.xdut.xfa1_1.xxor2.m0[l] = agauss(xor_m0l, 18n, 3)
  alter @m.xdut.xfa1_1.xxor2.m1[w] = agauss(xor_m1w, 18n, 3)
  alter @m.xdut.xfa1_1.xxor2.m1[l] = agauss(xor_m1l, 18n, 3)
  alter @m.xdut.xfa1_1.xxor2.m2[w] = agauss(xor_m2w, 18n, 3)
  alter @m.xdut.xfa1_1.xxor2.m2[l] = agauss(xor_m2l, 18n, 3)
  alter @m.xdut.xfa1_1.xxor2.m3[w] = agauss(xor_m3w, 18n, 3)
  alter @m.xdut.xfa1_1.xxor2.m3[l] = agauss(xor_m3l, 18n, 3)
  alter @m.xdut.xfa1_1.xxor2.m4[w] = agauss(xor_m4w, 18n, 3)
  alter @m.xdut.xfa1_1.xxor2.m4[l] = agauss(xor_m4l, 18n, 3)
  alter @m.xdut.xfa1_1.xxor2.m5[w] = agauss(xor_m5w, 18n, 3)
  alter @m.xdut.xfa1_1.xxor2.m5[l] = agauss(xor_m5l, 18n, 3)
  alter @m.xdut.xfa1_1.xxor2.m6[w] = agauss(xor_m6w, 18n, 3)
  alter @m.xdut.xfa1_1.xxor2.m6[l] = agauss(xor_m6l, 18n, 3)
  alter @m.xdut.xfa1_1.xxor2.m7[w] = agauss(xor_m7w, 18n, 3)
  alter @m.xdut.xfa1_1.xxor2.m7[l] = agauss(xor_m7l, 18n, 3)
  alter @m.xdut.xfa1_1.xxor2.m8[w] = agauss(xor_m8w, 18n, 3)
  alter @m.xdut.xfa1_1.xxor2.m8[l] = agauss(xor_m8l, 18n, 3)
  alter @m.xdut.xfa1_1.xxor2.m9[w] = agauss(xor_m9w, 18n, 3)
  alter @m.xdut.xfa1_1.xxor2.m9[l] = agauss(xor_m9l, 18n, 3)
  alter @m.xdut.xfa1_1.xmux1.mo0[w] = agauss(mux_mo0w, 18n, 3)
  alter @m.xdut.xfa1_1.xmux1.mo0[l] = agauss(mux_mo0l, 18n, 3)
  alter @m.xdut.xfa1_1.xmux1.mo1[w] = agauss(mux_mo1w, 18n, 3)
  alter @m.xdut.xfa1_1.xmux1.mo1[l] = agauss(mux_mo1l, 18n, 3)
  alter @m.xdut.xfa1_1.xmux1.m0[w] = agauss(mux_m0w, 18n, 3)
  alter @m.xdut.xfa1_1.xmux1.m0[l] = agauss(mux_m0l, 18n, 3)
  alter @m.xdut.xfa1_1.xmux1.m1[w] = agauss(mux_m1w, 18n, 3)
  alter @m.xdut.xfa1_1.xmux1.m1[l] = agauss(mux_m1l, 18n, 3)
  alter @m.xdut.xfa1_1.xmux1.m2[w] = agauss(mux_m2w, 18n, 3)
  alter @m.xdut.xfa1_1.xmux1.m2[l] = agauss(mux_m2l, 18n, 3)
  alter @m.xdut.xfa1_1.xmux1.m3[w] = agauss(mux_m3w, 18n, 3)
  alter @m.xdut.xfa1_1.xmux1.m3[l] = agauss(mux_m3l, 18n, 3)
  alter @m.xdut.xfa1_1.xmux1.m4[w] = agauss(mux_m4w, 18n, 3)
  alter @m.xdut.xfa1_1.xmux1.m4[l] = agauss(mux_m4l, 18n, 3)
  alter @m.xdut.xfa1_1.xmux1.m5[w] = agauss(mux_m5w, 18n, 3)
  alter @m.xdut.xfa1_1.xmux1.m5[l] = agauss(mux_m5l, 18n, 3)
  alter @m.xdut.xfa1_1.xmux1.m6[w] = agauss(mux_m6w, 18n, 3)
  alter @m.xdut.xfa1_1.xmux1.m6[l] = agauss(mux_m6l, 18n, 3)
  alter @m.xdut.xfa1_1.xmux1.m7[w] = agauss(mux_m7w, 18n, 3)
  alter @m.xdut.xfa1_1.xmux1.m7[l] = agauss(mux_m7l, 18n, 3)
  alter @m.xdut.xfa1_1.xmux1.m8[w] = agauss(mux_m8w, 18n, 3)
  alter @m.xdut.xfa1_1.xmux1.m8[l] = agauss(mux_m8l, 18n, 3)
  alter @m.xdut.xfa1_1.xmux1.m9[w] = agauss(mux_m9w, 18n, 3)
  alter @m.xdut.xfa1_1.xmux1.m9[l] = agauss(mux_m9l, 18n, 3)
  alter @m.xdut.xfa2_0.xxor1.m0[w] = agauss(xor_m0w, 18n, 3)
  alter @m.xdut.xfa2_0.xxor1.m0[l] = agauss(xor_m0l, 18n, 3)
  alter @m.xdut.xfa2_0.xxor1.m1[w] = agauss(xor_m1w, 18n, 3)
  alter @m.xdut.xfa2_0.xxor1.m1[l] = agauss(xor_m1l, 18n, 3)
  alter @m.xdut.xfa2_0.xxor1.m2[w] = agauss(xor_m2w, 18n, 3)
  alter @m.xdut.xfa2_0.xxor1.m2[l] = agauss(xor_m2l, 18n, 3)
  alter @m.xdut.xfa2_0.xxor1.m3[w] = agauss(xor_m3w, 18n, 3)
  alter @m.xdut.xfa2_0.xxor1.m3[l] = agauss(xor_m3l, 18n, 3)
  alter @m.xdut.xfa2_0.xxor1.m4[w] = agauss(xor_m4w, 18n, 3)
  alter @m.xdut.xfa2_0.xxor1.m4[l] = agauss(xor_m4l, 18n, 3)
  alter @m.xdut.xfa2_0.xxor1.m5[w] = agauss(xor_m5w, 18n, 3)
  alter @m.xdut.xfa2_0.xxor1.m5[l] = agauss(xor_m5l, 18n, 3)
  alter @m.xdut.xfa2_0.xxor1.m6[w] = agauss(xor_m6w, 18n, 3)
  alter @m.xdut.xfa2_0.xxor1.m6[l] = agauss(xor_m6l, 18n, 3)
  alter @m.xdut.xfa2_0.xxor1.m7[w] = agauss(xor_m7w, 18n, 3)
  alter @m.xdut.xfa2_0.xxor1.m7[l] = agauss(xor_m7l, 18n, 3)
  alter @m.xdut.xfa2_0.xxor1.m8[w] = agauss(xor_m8w, 18n, 3)
  alter @m.xdut.xfa2_0.xxor1.m8[l] = agauss(xor_m8l, 18n, 3)
  alter @m.xdut.xfa2_0.xxor1.m9[w] = agauss(xor_m9w, 18n, 3)
  alter @m.xdut.xfa2_0.xxor1.m9[l] = agauss(xor_m9l, 18n, 3)
  alter @m.xdut.xfa2_0.xxor2.m0[w] = agauss(xor_m0w, 18n, 3)
  alter @m.xdut.xfa2_0.xxor2.m0[l] = agauss(xor_m0l, 18n, 3)
  alter @m.xdut.xfa2_0.xxor2.m1[w] = agauss(xor_m1w, 18n, 3)
  alter @m.xdut.xfa2_0.xxor2.m1[l] = agauss(xor_m1l, 18n, 3)
  alter @m.xdut.xfa2_0.xxor2.m2[w] = agauss(xor_m2w, 18n, 3)
  alter @m.xdut.xfa2_0.xxor2.m2[l] = agauss(xor_m2l, 18n, 3)
  alter @m.xdut.xfa2_0.xxor2.m3[w] = agauss(xor_m3w, 18n, 3)
  alter @m.xdut.xfa2_0.xxor2.m3[l] = agauss(xor_m3l, 18n, 3)
  alter @m.xdut.xfa2_0.xxor2.m4[w] = agauss(xor_m4w, 18n, 3)
  alter @m.xdut.xfa2_0.xxor2.m4[l] = agauss(xor_m4l, 18n, 3)
  alter @m.xdut.xfa2_0.xxor2.m5[w] = agauss(xor_m5w, 18n, 3)
  alter @m.xdut.xfa2_0.xxor2.m5[l] = agauss(xor_m5l, 18n, 3)
  alter @m.xdut.xfa2_0.xxor2.m6[w] = agauss(xor_m6w, 18n, 3)
  alter @m.xdut.xfa2_0.xxor2.m6[l] = agauss(xor_m6l, 18n, 3)
  alter @m.xdut.xfa2_0.xxor2.m7[w] = agauss(xor_m7w, 18n, 3)
  alter @m.xdut.xfa2_0.xxor2.m7[l] = agauss(xor_m7l, 18n, 3)
  alter @m.xdut.xfa2_0.xxor2.m8[w] = agauss(xor_m8w, 18n, 3)
  alter @m.xdut.xfa2_0.xxor2.m8[l] = agauss(xor_m8l, 18n, 3)
  alter @m.xdut.xfa2_0.xxor2.m9[w] = agauss(xor_m9w, 18n, 3)
  alter @m.xdut.xfa2_0.xxor2.m9[l] = agauss(xor_m9l, 18n, 3)
  alter @m.xdut.xfa2_0.xmux1.mo0[w] = agauss(mux_mo0w, 18n, 3)
  alter @m.xdut.xfa2_0.xmux1.mo0[l] = agauss(mux_mo0l, 18n, 3)
  alter @m.xdut.xfa2_0.xmux1.mo1[w] = agauss(mux_mo1w, 18n, 3)
  alter @m.xdut.xfa2_0.xmux1.mo1[l] = agauss(mux_mo1l, 18n, 3)
  alter @m.xdut.xfa2_0.xmux1.m0[w] = agauss(mux_m0w, 18n, 3)
  alter @m.xdut.xfa2_0.xmux1.m0[l] = agauss(mux_m0l, 18n, 3)
  alter @m.xdut.xfa2_0.xmux1.m1[w] = agauss(mux_m1w, 18n, 3)
  alter @m.xdut.xfa2_0.xmux1.m1[l] = agauss(mux_m1l, 18n, 3)
  alter @m.xdut.xfa2_0.xmux1.m2[w] = agauss(mux_m2w, 18n, 3)
  alter @m.xdut.xfa2_0.xmux1.m2[l] = agauss(mux_m2l, 18n, 3)
  alter @m.xdut.xfa2_0.xmux1.m3[w] = agauss(mux_m3w, 18n, 3)
  alter @m.xdut.xfa2_0.xmux1.m3[l] = agauss(mux_m3l, 18n, 3)
  alter @m.xdut.xfa2_0.xmux1.m4[w] = agauss(mux_m4w, 18n, 3)
  alter @m.xdut.xfa2_0.xmux1.m4[l] = agauss(mux_m4l, 18n, 3)
  alter @m.xdut.xfa2_0.xmux1.m5[w] = agauss(mux_m5w, 18n, 3)
  alter @m.xdut.xfa2_0.xmux1.m5[l] = agauss(mux_m5l, 18n, 3)
  alter @m.xdut.xfa2_0.xmux1.m6[w] = agauss(mux_m6w, 18n, 3)
  alter @m.xdut.xfa2_0.xmux1.m6[l] = agauss(mux_m6l, 18n, 3)
  alter @m.xdut.xfa2_0.xmux1.m7[w] = agauss(mux_m7w, 18n, 3)
  alter @m.xdut.xfa2_0.xmux1.m7[l] = agauss(mux_m7l, 18n, 3)
  alter @m.xdut.xfa2_0.xmux1.m8[w] = agauss(mux_m8w, 18n, 3)
  alter @m.xdut.xfa2_0.xmux1.m8[l] = agauss(mux_m8l, 18n, 3)
  alter @m.xdut.xfa2_0.xmux1.m9[w] = agauss(mux_m9w, 18n, 3)
  alter @m.xdut.xfa2_0.xmux1.m9[l] = agauss(mux_m9l, 18n, 3)
  alter @m.xdut.xfa2_1.xxor1.m0[w] = agauss(xor_m0w, 18n, 3)
  alter @m.xdut.xfa2_1.xxor1.m0[l] = agauss(xor_m0l, 18n, 3)
  alter @m.xdut.xfa2_1.xxor1.m1[w] = agauss(xor_m1w, 18n, 3)
  alter @m.xdut.xfa2_1.xxor1.m1[l] = agauss(xor_m1l, 18n, 3)
  alter @m.xdut.xfa2_1.xxor1.m2[w] = agauss(xor_m2w, 18n, 3)
  alter @m.xdut.xfa2_1.xxor1.m2[l] = agauss(xor_m2l, 18n, 3)
  alter @m.xdut.xfa2_1.xxor1.m3[w] = agauss(xor_m3w, 18n, 3)
  alter @m.xdut.xfa2_1.xxor1.m3[l] = agauss(xor_m3l, 18n, 3)
  alter @m.xdut.xfa2_1.xxor1.m4[w] = agauss(xor_m4w, 18n, 3)
  alter @m.xdut.xfa2_1.xxor1.m4[l] = agauss(xor_m4l, 18n, 3)
  alter @m.xdut.xfa2_1.xxor1.m5[w] = agauss(xor_m5w, 18n, 3)
  alter @m.xdut.xfa2_1.xxor1.m5[l] = agauss(xor_m5l, 18n, 3)
  alter @m.xdut.xfa2_1.xxor1.m6[w] = agauss(xor_m6w, 18n, 3)
  alter @m.xdut.xfa2_1.xxor1.m6[l] = agauss(xor_m6l, 18n, 3)
  alter @m.xdut.xfa2_1.xxor1.m7[w] = agauss(xor_m7w, 18n, 3)
  alter @m.xdut.xfa2_1.xxor1.m7[l] = agauss(xor_m7l, 18n, 3)
  alter @m.xdut.xfa2_1.xxor1.m8[w] = agauss(xor_m8w, 18n, 3)
  alter @m.xdut.xfa2_1.xxor1.m8[l] = agauss(xor_m8l, 18n, 3)
  alter @m.xdut.xfa2_1.xxor1.m9[w] = agauss(xor_m9w, 18n, 3)
  alter @m.xdut.xfa2_1.xxor1.m9[l] = agauss(xor_m9l, 18n, 3)
  alter @m.xdut.xfa2_1.xxor2.m0[w] = agauss(xor_m0w, 18n, 3)
  alter @m.xdut.xfa2_1.xxor2.m0[l] = agauss(xor_m0l, 18n, 3)
  alter @m.xdut.xfa2_1.xxor2.m1[w] = agauss(xor_m1w, 18n, 3)
  alter @m.xdut.xfa2_1.xxor2.m1[l] = agauss(xor_m1l, 18n, 3)
  alter @m.xdut.xfa2_1.xxor2.m2[w] = agauss(xor_m2w, 18n, 3)
  alter @m.xdut.xfa2_1.xxor2.m2[l] = agauss(xor_m2l, 18n, 3)
  alter @m.xdut.xfa2_1.xxor2.m3[w] = agauss(xor_m3w, 18n, 3)
  alter @m.xdut.xfa2_1.xxor2.m3[l] = agauss(xor_m3l, 18n, 3)
  alter @m.xdut.xfa2_1.xxor2.m4[w] = agauss(xor_m4w, 18n, 3)
  alter @m.xdut.xfa2_1.xxor2.m4[l] = agauss(xor_m4l, 18n, 3)
  alter @m.xdut.xfa2_1.xxor2.m5[w] = agauss(xor_m5w, 18n, 3)
  alter @m.xdut.xfa2_1.xxor2.m5[l] = agauss(xor_m5l, 18n, 3)
  alter @m.xdut.xfa2_1.xxor2.m6[w] = agauss(xor_m6w, 18n, 3)
  alter @m.xdut.xfa2_1.xxor2.m6[l] = agauss(xor_m6l, 18n, 3)
  alter @m.xdut.xfa2_1.xxor2.m7[w] = agauss(xor_m7w, 18n, 3)
  alter @m.xdut.xfa2_1.xxor2.m7[l] = agauss(xor_m7l, 18n, 3)
  alter @m.xdut.xfa2_1.xxor2.m8[w] = agauss(xor_m8w, 18n, 3)
  alter @m.xdut.xfa2_1.xxor2.m8[l] = agauss(xor_m8l, 18n, 3)
  alter @m.xdut.xfa2_1.xxor2.m9[w] = agauss(xor_m9w, 18n, 3)
  alter @m.xdut.xfa2_1.xxor2.m9[l] = agauss(xor_m9l, 18n, 3)
  alter @m.xdut.xfa2_1.xmux1.mo0[w] = agauss(mux_mo0w, 18n, 3)
  alter @m.xdut.xfa2_1.xmux1.mo0[l] = agauss(mux_mo0l, 18n, 3)
  alter @m.xdut.xfa2_1.xmux1.mo1[w] = agauss(mux_mo1w, 18n, 3)
  alter @m.xdut.xfa2_1.xmux1.mo1[l] = agauss(mux_mo1l, 18n, 3)
  alter @m.xdut.xfa2_1.xmux1.m0[w] = agauss(mux_m0w, 18n, 3)
  alter @m.xdut.xfa2_1.xmux1.m0[l] = agauss(mux_m0l, 18n, 3)
  alter @m.xdut.xfa2_1.xmux1.m1[w] = agauss(mux_m1w, 18n, 3)
  alter @m.xdut.xfa2_1.xmux1.m1[l] = agauss(mux_m1l, 18n, 3)
  alter @m.xdut.xfa2_1.xmux1.m2[w] = agauss(mux_m2w, 18n, 3)
  alter @m.xdut.xfa2_1.xmux1.m2[l] = agauss(mux_m2l, 18n, 3)
  alter @m.xdut.xfa2_1.xmux1.m3[w] = agauss(mux_m3w, 18n, 3)
  alter @m.xdut.xfa2_1.xmux1.m3[l] = agauss(mux_m3l, 18n, 3)
  alter @m.xdut.xfa2_1.xmux1.m4[w] = agauss(mux_m4w, 18n, 3)
  alter @m.xdut.xfa2_1.xmux1.m4[l] = agauss(mux_m4l, 18n, 3)
  alter @m.xdut.xfa2_1.xmux1.m5[w] = agauss(mux_m5w, 18n, 3)
  alter @m.xdut.xfa2_1.xmux1.m5[l] = agauss(mux_m5l, 18n, 3)
  alter @m.xdut.xfa2_1.xmux1.m6[w] = agauss(mux_m6w, 18n, 3)
  alter @m.xdut.xfa2_1.xmux1.m6[l] = agauss(mux_m6l, 18n, 3)
  alter @m.xdut.xfa2_1.xmux1.m7[w] = agauss(mux_m7w, 18n, 3)
  alter @m.xdut.xfa2_1.xmux1.m7[l] = agauss(mux_m7l, 18n, 3)
  alter @m.xdut.xfa2_1.xmux1.m8[w] = agauss(mux_m8w, 18n, 3)
  alter @m.xdut.xfa2_1.xmux1.m8[l] = agauss(mux_m8l, 18n, 3)
  alter @m.xdut.xfa2_1.xmux1.m9[w] = agauss(mux_m9w, 18n, 3)
  alter @m.xdut.xfa2_1.xmux1.m9[l] = agauss(mux_m9l, 18n, 3)
  alter @m.xdut.xfa3_0.xxor1.m0[w] = agauss(xor_m0w, 18n, 3)
  alter @m.xdut.xfa3_0.xxor1.m0[l] = agauss(xor_m0l, 18n, 3)
  alter @m.xdut.xfa3_0.xxor1.m1[w] = agauss(xor_m1w, 18n, 3)
  alter @m.xdut.xfa3_0.xxor1.m1[l] = agauss(xor_m1l, 18n, 3)
  alter @m.xdut.xfa3_0.xxor1.m2[w] = agauss(xor_m2w, 18n, 3)
  alter @m.xdut.xfa3_0.xxor1.m2[l] = agauss(xor_m2l, 18n, 3)
  alter @m.xdut.xfa3_0.xxor1.m3[w] = agauss(xor_m3w, 18n, 3)
  alter @m.xdut.xfa3_0.xxor1.m3[l] = agauss(xor_m3l, 18n, 3)
  alter @m.xdut.xfa3_0.xxor1.m4[w] = agauss(xor_m4w, 18n, 3)
  alter @m.xdut.xfa3_0.xxor1.m4[l] = agauss(xor_m4l, 18n, 3)
  alter @m.xdut.xfa3_0.xxor1.m5[w] = agauss(xor_m5w, 18n, 3)
  alter @m.xdut.xfa3_0.xxor1.m5[l] = agauss(xor_m5l, 18n, 3)
  alter @m.xdut.xfa3_0.xxor1.m6[w] = agauss(xor_m6w, 18n, 3)
  alter @m.xdut.xfa3_0.xxor1.m6[l] = agauss(xor_m6l, 18n, 3)
  alter @m.xdut.xfa3_0.xxor1.m7[w] = agauss(xor_m7w, 18n, 3)
  alter @m.xdut.xfa3_0.xxor1.m7[l] = agauss(xor_m7l, 18n, 3)
  alter @m.xdut.xfa3_0.xxor1.m8[w] = agauss(xor_m8w, 18n, 3)
  alter @m.xdut.xfa3_0.xxor1.m8[l] = agauss(xor_m8l, 18n, 3)
  alter @m.xdut.xfa3_0.xxor1.m9[w] = agauss(xor_m9w, 18n, 3)
  alter @m.xdut.xfa3_0.xxor1.m9[l] = agauss(xor_m9l, 18n, 3)
  alter @m.xdut.xfa3_0.xxor2.m0[w] = agauss(xor_m0w, 18n, 3)
  alter @m.xdut.xfa3_0.xxor2.m0[l] = agauss(xor_m0l, 18n, 3)
  alter @m.xdut.xfa3_0.xxor2.m1[w] = agauss(xor_m1w, 18n, 3)
  alter @m.xdut.xfa3_0.xxor2.m1[l] = agauss(xor_m1l, 18n, 3)
  alter @m.xdut.xfa3_0.xxor2.m2[w] = agauss(xor_m2w, 18n, 3)
  alter @m.xdut.xfa3_0.xxor2.m2[l] = agauss(xor_m2l, 18n, 3)
  alter @m.xdut.xfa3_0.xxor2.m3[w] = agauss(xor_m3w, 18n, 3)
  alter @m.xdut.xfa3_0.xxor2.m3[l] = agauss(xor_m3l, 18n, 3)
  alter @m.xdut.xfa3_0.xxor2.m4[w] = agauss(xor_m4w, 18n, 3)
  alter @m.xdut.xfa3_0.xxor2.m4[l] = agauss(xor_m4l, 18n, 3)
  alter @m.xdut.xfa3_0.xxor2.m5[w] = agauss(xor_m5w, 18n, 3)
  alter @m.xdut.xfa3_0.xxor2.m5[l] = agauss(xor_m5l, 18n, 3)
  alter @m.xdut.xfa3_0.xxor2.m6[w] = agauss(xor_m6w, 18n, 3)
  alter @m.xdut.xfa3_0.xxor2.m6[l] = agauss(xor_m6l, 18n, 3)
  alter @m.xdut.xfa3_0.xxor2.m7[w] = agauss(xor_m7w, 18n, 3)
  alter @m.xdut.xfa3_0.xxor2.m7[l] = agauss(xor_m7l, 18n, 3)
  alter @m.xdut.xfa3_0.xxor2.m8[w] = agauss(xor_m8w, 18n, 3)
  alter @m.xdut.xfa3_0.xxor2.m8[l] = agauss(xor_m8l, 18n, 3)
  alter @m.xdut.xfa3_0.xxor2.m9[w] = agauss(xor_m9w, 18n, 3)
  alter @m.xdut.xfa3_0.xxor2.m9[l] = agauss(xor_m9l, 18n, 3)
  alter @m.xdut.xfa3_0.xmux1.mo0[w] = agauss(mux_mo0w, 18n, 3)
  alter @m.xdut.xfa3_0.xmux1.mo0[l] = agauss(mux_mo0l, 18n, 3)
  alter @m.xdut.xfa3_0.xmux1.mo1[w] = agauss(mux_mo1w, 18n, 3)
  alter @m.xdut.xfa3_0.xmux1.mo1[l] = agauss(mux_mo1l, 18n, 3)
  alter @m.xdut.xfa3_0.xmux1.m0[w] = agauss(mux_m0w, 18n, 3)
  alter @m.xdut.xfa3_0.xmux1.m0[l] = agauss(mux_m0l, 18n, 3)
  alter @m.xdut.xfa3_0.xmux1.m1[w] = agauss(mux_m1w, 18n, 3)
  alter @m.xdut.xfa3_0.xmux1.m1[l] = agauss(mux_m1l, 18n, 3)
  alter @m.xdut.xfa3_0.xmux1.m2[w] = agauss(mux_m2w, 18n, 3)
  alter @m.xdut.xfa3_0.xmux1.m2[l] = agauss(mux_m2l, 18n, 3)
  alter @m.xdut.xfa3_0.xmux1.m3[w] = agauss(mux_m3w, 18n, 3)
  alter @m.xdut.xfa3_0.xmux1.m3[l] = agauss(mux_m3l, 18n, 3)
  alter @m.xdut.xfa3_0.xmux1.m4[w] = agauss(mux_m4w, 18n, 3)
  alter @m.xdut.xfa3_0.xmux1.m4[l] = agauss(mux_m4l, 18n, 3)
  alter @m.xdut.xfa3_0.xmux1.m5[w] = agauss(mux_m5w, 18n, 3)
  alter @m.xdut.xfa3_0.xmux1.m5[l] = agauss(mux_m5l, 18n, 3)
  alter @m.xdut.xfa3_0.xmux1.m6[w] = agauss(mux_m6w, 18n, 3)
  alter @m.xdut.xfa3_0.xmux1.m6[l] = agauss(mux_m6l, 18n, 3)
  alter @m.xdut.xfa3_0.xmux1.m7[w] = agauss(mux_m7w, 18n, 3)
  alter @m.xdut.xfa3_0.xmux1.m7[l] = agauss(mux_m7l, 18n, 3)
  alter @m.xdut.xfa3_0.xmux1.m8[w] = agauss(mux_m8w, 18n, 3)
  alter @m.xdut.xfa3_0.xmux1.m8[l] = agauss(mux_m8l, 18n, 3)
  alter @m.xdut.xfa3_0.xmux1.m9[w] = agauss(mux_m9w, 18n, 3)
  alter @m.xdut.xfa3_0.xmux1.m9[l] = agauss(mux_m9l, 18n, 3)
  alter @m.xdut.xfa3_1.xxor1.m0[w] = agauss(xor_m0w, 18n, 3)
  alter @m.xdut.xfa3_1.xxor1.m0[l] = agauss(xor_m0l, 18n, 3)
  alter @m.xdut.xfa3_1.xxor1.m1[w] = agauss(xor_m1w, 18n, 3)
  alter @m.xdut.xfa3_1.xxor1.m1[l] = agauss(xor_m1l, 18n, 3)
  alter @m.xdut.xfa3_1.xxor1.m2[w] = agauss(xor_m2w, 18n, 3)
  alter @m.xdut.xfa3_1.xxor1.m2[l] = agauss(xor_m2l, 18n, 3)
  alter @m.xdut.xfa3_1.xxor1.m3[w] = agauss(xor_m3w, 18n, 3)
  alter @m.xdut.xfa3_1.xxor1.m3[l] = agauss(xor_m3l, 18n, 3)
  alter @m.xdut.xfa3_1.xxor1.m4[w] = agauss(xor_m4w, 18n, 3)
  alter @m.xdut.xfa3_1.xxor1.m4[l] = agauss(xor_m4l, 18n, 3)
  alter @m.xdut.xfa3_1.xxor1.m5[w] = agauss(xor_m5w, 18n, 3)
  alter @m.xdut.xfa3_1.xxor1.m5[l] = agauss(xor_m5l, 18n, 3)
  alter @m.xdut.xfa3_1.xxor1.m6[w] = agauss(xor_m6w, 18n, 3)
  alter @m.xdut.xfa3_1.xxor1.m6[l] = agauss(xor_m6l, 18n, 3)
  alter @m.xdut.xfa3_1.xxor1.m7[w] = agauss(xor_m7w, 18n, 3)
  alter @m.xdut.xfa3_1.xxor1.m7[l] = agauss(xor_m7l, 18n, 3)
  alter @m.xdut.xfa3_1.xxor1.m8[w] = agauss(xor_m8w, 18n, 3)
  alter @m.xdut.xfa3_1.xxor1.m8[l] = agauss(xor_m8l, 18n, 3)
  alter @m.xdut.xfa3_1.xxor1.m9[w] = agauss(xor_m9w, 18n, 3)
  alter @m.xdut.xfa3_1.xxor1.m9[l] = agauss(xor_m9l, 18n, 3)
  alter @m.xdut.xfa3_1.xxor2.m0[w] = agauss(xor_m0w, 18n, 3)
  alter @m.xdut.xfa3_1.xxor2.m0[l] = agauss(xor_m0l, 18n, 3)
  alter @m.xdut.xfa3_1.xxor2.m1[w] = agauss(xor_m1w, 18n, 3)
  alter @m.xdut.xfa3_1.xxor2.m1[l] = agauss(xor_m1l, 18n, 3)
  alter @m.xdut.xfa3_1.xxor2.m2[w] = agauss(xor_m2w, 18n, 3)
  alter @m.xdut.xfa3_1.xxor2.m2[l] = agauss(xor_m2l, 18n, 3)
  alter @m.xdut.xfa3_1.xxor2.m3[w] = agauss(xor_m3w, 18n, 3)
  alter @m.xdut.xfa3_1.xxor2.m3[l] = agauss(xor_m3l, 18n, 3)
  alter @m.xdut.xfa3_1.xxor2.m4[w] = agauss(xor_m4w, 18n, 3)
  alter @m.xdut.xfa3_1.xxor2.m4[l] = agauss(xor_m4l, 18n, 3)
  alter @m.xdut.xfa3_1.xxor2.m5[w] = agauss(xor_m5w, 18n, 3)
  alter @m.xdut.xfa3_1.xxor2.m5[l] = agauss(xor_m5l, 18n, 3)
  alter @m.xdut.xfa3_1.xxor2.m6[w] = agauss(xor_m6w, 18n, 3)
  alter @m.xdut.xfa3_1.xxor2.m6[l] = agauss(xor_m6l, 18n, 3)
  alter @m.xdut.xfa3_1.xxor2.m7[w] = agauss(xor_m7w, 18n, 3)
  alter @m.xdut.xfa3_1.xxor2.m7[l] = agauss(xor_m7l, 18n, 3)
  alter @m.xdut.xfa3_1.xxor2.m8[w] = agauss(xor_m8w, 18n, 3)
  alter @m.xdut.xfa3_1.xxor2.m8[l] = agauss(xor_m8l, 18n, 3)
  alter @m.xdut.xfa3_1.xxor2.m9[w] = agauss(xor_m9w, 18n, 3)
  alter @m.xdut.xfa3_1.xxor2.m9[l] = agauss(xor_m9l, 18n, 3)
  alter @m.xdut.xfa3_1.xmux1.mo0[w] = agauss(mux_mo0w, 18n, 3)
  alter @m.xdut.xfa3_1.xmux1.mo0[l] = agauss(mux_mo0l, 18n, 3)
  alter @m.xdut.xfa3_1.xmux1.mo1[w] = agauss(mux_mo1w, 18n, 3)
  alter @m.xdut.xfa3_1.xmux1.mo1[l] = agauss(mux_mo1l, 18n, 3)
  alter @m.xdut.xfa3_1.xmux1.m0[w] = agauss(mux_m0w, 18n, 3)
  alter @m.xdut.xfa3_1.xmux1.m0[l] = agauss(mux_m0l, 18n, 3)
  alter @m.xdut.xfa3_1.xmux1.m1[w] = agauss(mux_m1w, 18n, 3)
  alter @m.xdut.xfa3_1.xmux1.m1[l] = agauss(mux_m1l, 18n, 3)
  alter @m.xdut.xfa3_1.xmux1.m2[w] = agauss(mux_m2w, 18n, 3)
  alter @m.xdut.xfa3_1.xmux1.m2[l] = agauss(mux_m2l, 18n, 3)
  alter @m.xdut.xfa3_1.xmux1.m3[w] = agauss(mux_m3w, 18n, 3)
  alter @m.xdut.xfa3_1.xmux1.m3[l] = agauss(mux_m3l, 18n, 3)
  alter @m.xdut.xfa3_1.xmux1.m4[w] = agauss(mux_m4w, 18n, 3)
  alter @m.xdut.xfa3_1.xmux1.m4[l] = agauss(mux_m4l, 18n, 3)
  alter @m.xdut.xfa3_1.xmux1.m5[w] = agauss(mux_m5w, 18n, 3)
  alter @m.xdut.xfa3_1.xmux1.m5[l] = agauss(mux_m5l, 18n, 3)
  alter @m.xdut.xfa3_1.xmux1.m6[w] = agauss(mux_m6w, 18n, 3)
  alter @m.xdut.xfa3_1.xmux1.m6[l] = agauss(mux_m6l, 18n, 3)
  alter @m.xdut.xfa3_1.xmux1.m7[w] = agauss(mux_m7w, 18n, 3)
  alter @m.xdut.xfa3_1.xmux1.m7[l] = agauss(mux_m7l, 18n, 3)
  alter @m.xdut.xfa3_1.xmux1.m8[w] = agauss(mux_m8w, 18n, 3)
  alter @m.xdut.xfa3_1.xmux1.m8[l] = agauss(mux_m8l, 18n, 3)
  alter @m.xdut.xfa3_1.xmux1.m9[w] = agauss(mux_m9w, 18n, 3)
  alter @m.xdut.xfa3_1.xmux1.m9[l] = agauss(mux_m9l, 18n, 3)
  alter @m.xdut.xfa4_0.xxor1.m0[w] = agauss(xor_m0w, 18n, 3)
  alter @m.xdut.xfa4_0.xxor1.m0[l] = agauss(xor_m0l, 18n, 3)
  alter @m.xdut.xfa4_0.xxor1.m1[w] = agauss(xor_m1w, 18n, 3)
  alter @m.xdut.xfa4_0.xxor1.m1[l] = agauss(xor_m1l, 18n, 3)
  alter @m.xdut.xfa4_0.xxor1.m2[w] = agauss(xor_m2w, 18n, 3)
  alter @m.xdut.xfa4_0.xxor1.m2[l] = agauss(xor_m2l, 18n, 3)
  alter @m.xdut.xfa4_0.xxor1.m3[w] = agauss(xor_m3w, 18n, 3)
  alter @m.xdut.xfa4_0.xxor1.m3[l] = agauss(xor_m3l, 18n, 3)
  alter @m.xdut.xfa4_0.xxor1.m4[w] = agauss(xor_m4w, 18n, 3)
  alter @m.xdut.xfa4_0.xxor1.m4[l] = agauss(xor_m4l, 18n, 3)
  alter @m.xdut.xfa4_0.xxor1.m5[w] = agauss(xor_m5w, 18n, 3)
  alter @m.xdut.xfa4_0.xxor1.m5[l] = agauss(xor_m5l, 18n, 3)
  alter @m.xdut.xfa4_0.xxor1.m6[w] = agauss(xor_m6w, 18n, 3)
  alter @m.xdut.xfa4_0.xxor1.m6[l] = agauss(xor_m6l, 18n, 3)
  alter @m.xdut.xfa4_0.xxor1.m7[w] = agauss(xor_m7w, 18n, 3)
  alter @m.xdut.xfa4_0.xxor1.m7[l] = agauss(xor_m7l, 18n, 3)
  alter @m.xdut.xfa4_0.xxor1.m8[w] = agauss(xor_m8w, 18n, 3)
  alter @m.xdut.xfa4_0.xxor1.m8[l] = agauss(xor_m8l, 18n, 3)
  alter @m.xdut.xfa4_0.xxor1.m9[w] = agauss(xor_m9w, 18n, 3)
  alter @m.xdut.xfa4_0.xxor1.m9[l] = agauss(xor_m9l, 18n, 3)
  alter @m.xdut.xfa4_0.xxor2.m0[w] = agauss(xor_m0w, 18n, 3)
  alter @m.xdut.xfa4_0.xxor2.m0[l] = agauss(xor_m0l, 18n, 3)
  alter @m.xdut.xfa4_0.xxor2.m1[w] = agauss(xor_m1w, 18n, 3)
  alter @m.xdut.xfa4_0.xxor2.m1[l] = agauss(xor_m1l, 18n, 3)
  alter @m.xdut.xfa4_0.xxor2.m2[w] = agauss(xor_m2w, 18n, 3)
  alter @m.xdut.xfa4_0.xxor2.m2[l] = agauss(xor_m2l, 18n, 3)
  alter @m.xdut.xfa4_0.xxor2.m3[w] = agauss(xor_m3w, 18n, 3)
  alter @m.xdut.xfa4_0.xxor2.m3[l] = agauss(xor_m3l, 18n, 3)
  alter @m.xdut.xfa4_0.xxor2.m4[w] = agauss(xor_m4w, 18n, 3)
  alter @m.xdut.xfa4_0.xxor2.m4[l] = agauss(xor_m4l, 18n, 3)
  alter @m.xdut.xfa4_0.xxor2.m5[w] = agauss(xor_m5w, 18n, 3)
  alter @m.xdut.xfa4_0.xxor2.m5[l] = agauss(xor_m5l, 18n, 3)
  alter @m.xdut.xfa4_0.xxor2.m6[w] = agauss(xor_m6w, 18n, 3)
  alter @m.xdut.xfa4_0.xxor2.m6[l] = agauss(xor_m6l, 18n, 3)
  alter @m.xdut.xfa4_0.xxor2.m7[w] = agauss(xor_m7w, 18n, 3)
  alter @m.xdut.xfa4_0.xxor2.m7[l] = agauss(xor_m7l, 18n, 3)
  alter @m.xdut.xfa4_0.xxor2.m8[w] = agauss(xor_m8w, 18n, 3)
  alter @m.xdut.xfa4_0.xxor2.m8[l] = agauss(xor_m8l, 18n, 3)
  alter @m.xdut.xfa4_0.xxor2.m9[w] = agauss(xor_m9w, 18n, 3)
  alter @m.xdut.xfa4_0.xxor2.m9[l] = agauss(xor_m9l, 18n, 3)
  alter @m.xdut.xfa4_0.xmux1.mo0[w] = agauss(mux_mo0w, 18n, 3)
  alter @m.xdut.xfa4_0.xmux1.mo0[l] = agauss(mux_mo0l, 18n, 3)
  alter @m.xdut.xfa4_0.xmux1.mo1[w] = agauss(mux_mo1w, 18n, 3)
  alter @m.xdut.xfa4_0.xmux1.mo1[l] = agauss(mux_mo1l, 18n, 3)
  alter @m.xdut.xfa4_0.xmux1.m0[w] = agauss(mux_m0w, 18n, 3)
  alter @m.xdut.xfa4_0.xmux1.m0[l] = agauss(mux_m0l, 18n, 3)
  alter @m.xdut.xfa4_0.xmux1.m1[w] = agauss(mux_m1w, 18n, 3)
  alter @m.xdut.xfa4_0.xmux1.m1[l] = agauss(mux_m1l, 18n, 3)
  alter @m.xdut.xfa4_0.xmux1.m2[w] = agauss(mux_m2w, 18n, 3)
  alter @m.xdut.xfa4_0.xmux1.m2[l] = agauss(mux_m2l, 18n, 3)
  alter @m.xdut.xfa4_0.xmux1.m3[w] = agauss(mux_m3w, 18n, 3)
  alter @m.xdut.xfa4_0.xmux1.m3[l] = agauss(mux_m3l, 18n, 3)
  alter @m.xdut.xfa4_0.xmux1.m4[w] = agauss(mux_m4w, 18n, 3)
  alter @m.xdut.xfa4_0.xmux1.m4[l] = agauss(mux_m4l, 18n, 3)
  alter @m.xdut.xfa4_0.xmux1.m5[w] = agauss(mux_m5w, 18n, 3)
  alter @m.xdut.xfa4_0.xmux1.m5[l] = agauss(mux_m5l, 18n, 3)
  alter @m.xdut.xfa4_0.xmux1.m6[w] = agauss(mux_m6w, 18n, 3)
  alter @m.xdut.xfa4_0.xmux1.m6[l] = agauss(mux_m6l, 18n, 3)
  alter @m.xdut.xfa4_0.xmux1.m7[w] = agauss(mux_m7w, 18n, 3)
  alter @m.xdut.xfa4_0.xmux1.m7[l] = agauss(mux_m7l, 18n, 3)
  alter @m.xdut.xfa4_0.xmux1.m8[w] = agauss(mux_m8w, 18n, 3)
  alter @m.xdut.xfa4_0.xmux1.m8[l] = agauss(mux_m8l, 18n, 3)
  alter @m.xdut.xfa4_0.xmux1.m9[w] = agauss(mux_m9w, 18n, 3)
  alter @m.xdut.xfa4_0.xmux1.m9[l] = agauss(mux_m9l, 18n, 3)
  alter @m.xdut.xfa4_1.xxor1.m0[w] = agauss(xor_m0w, 18n, 3)
  alter @m.xdut.xfa4_1.xxor1.m0[l] = agauss(xor_m0l, 18n, 3)
  alter @m.xdut.xfa4_1.xxor1.m1[w] = agauss(xor_m1w, 18n, 3)
  alter @m.xdut.xfa4_1.xxor1.m1[l] = agauss(xor_m1l, 18n, 3)
  alter @m.xdut.xfa4_1.xxor1.m2[w] = agauss(xor_m2w, 18n, 3)
  alter @m.xdut.xfa4_1.xxor1.m2[l] = agauss(xor_m2l, 18n, 3)
  alter @m.xdut.xfa4_1.xxor1.m3[w] = agauss(xor_m3w, 18n, 3)
  alter @m.xdut.xfa4_1.xxor1.m3[l] = agauss(xor_m3l, 18n, 3)
  alter @m.xdut.xfa4_1.xxor1.m4[w] = agauss(xor_m4w, 18n, 3)
  alter @m.xdut.xfa4_1.xxor1.m4[l] = agauss(xor_m4l, 18n, 3)
  alter @m.xdut.xfa4_1.xxor1.m5[w] = agauss(xor_m5w, 18n, 3)
  alter @m.xdut.xfa4_1.xxor1.m5[l] = agauss(xor_m5l, 18n, 3)
  alter @m.xdut.xfa4_1.xxor1.m6[w] = agauss(xor_m6w, 18n, 3)
  alter @m.xdut.xfa4_1.xxor1.m6[l] = agauss(xor_m6l, 18n, 3)
  alter @m.xdut.xfa4_1.xxor1.m7[w] = agauss(xor_m7w, 18n, 3)
  alter @m.xdut.xfa4_1.xxor1.m7[l] = agauss(xor_m7l, 18n, 3)
  alter @m.xdut.xfa4_1.xxor1.m8[w] = agauss(xor_m8w, 18n, 3)
  alter @m.xdut.xfa4_1.xxor1.m8[l] = agauss(xor_m8l, 18n, 3)
  alter @m.xdut.xfa4_1.xxor1.m9[w] = agauss(xor_m9w, 18n, 3)
  alter @m.xdut.xfa4_1.xxor1.m9[l] = agauss(xor_m9l, 18n, 3)
  alter @m.xdut.xfa4_1.xxor2.m0[w] = agauss(xor_m0w, 18n, 3)
  alter @m.xdut.xfa4_1.xxor2.m0[l] = agauss(xor_m0l, 18n, 3)
  alter @m.xdut.xfa4_1.xxor2.m1[w] = agauss(xor_m1w, 18n, 3)
  alter @m.xdut.xfa4_1.xxor2.m1[l] = agauss(xor_m1l, 18n, 3)
  alter @m.xdut.xfa4_1.xxor2.m2[w] = agauss(xor_m2w, 18n, 3)
  alter @m.xdut.xfa4_1.xxor2.m2[l] = agauss(xor_m2l, 18n, 3)
  alter @m.xdut.xfa4_1.xxor2.m3[w] = agauss(xor_m3w, 18n, 3)
  alter @m.xdut.xfa4_1.xxor2.m3[l] = agauss(xor_m3l, 18n, 3)
  alter @m.xdut.xfa4_1.xxor2.m4[w] = agauss(xor_m4w, 18n, 3)
  alter @m.xdut.xfa4_1.xxor2.m4[l] = agauss(xor_m4l, 18n, 3)
  alter @m.xdut.xfa4_1.xxor2.m5[w] = agauss(xor_m5w, 18n, 3)
  alter @m.xdut.xfa4_1.xxor2.m5[l] = agauss(xor_m5l, 18n, 3)
  alter @m.xdut.xfa4_1.xxor2.m6[w] = agauss(xor_m6w, 18n, 3)
  alter @m.xdut.xfa4_1.xxor2.m6[l] = agauss(xor_m6l, 18n, 3)
  alter @m.xdut.xfa4_1.xxor2.m7[w] = agauss(xor_m7w, 18n, 3)
  alter @m.xdut.xfa4_1.xxor2.m7[l] = agauss(xor_m7l, 18n, 3)
  alter @m.xdut.xfa4_1.xxor2.m8[w] = agauss(xor_m8w, 18n, 3)
  alter @m.xdut.xfa4_1.xxor2.m8[l] = agauss(xor_m8l, 18n, 3)
  alter @m.xdut.xfa4_1.xxor2.m9[w] = agauss(xor_m9w, 18n, 3)
  alter @m.xdut.xfa4_1.xxor2.m9[l] = agauss(xor_m9l, 18n, 3)
  alter @m.xdut.xfa4_1.xmux1.mo0[w] = agauss(mux_mo0w, 18n, 3)
  alter @m.xdut.xfa4_1.xmux1.mo0[l] = agauss(mux_mo0l, 18n, 3)
  alter @m.xdut.xfa4_1.xmux1.mo1[w] = agauss(mux_mo1w, 18n, 3)
  alter @m.xdut.xfa4_1.xmux1.mo1[l] = agauss(mux_mo1l, 18n, 3)
  alter @m.xdut.xfa4_1.xmux1.m0[w] = agauss(mux_m0w, 18n, 3)
  alter @m.xdut.xfa4_1.xmux1.m0[l] = agauss(mux_m0l, 18n, 3)
  alter @m.xdut.xfa4_1.xmux1.m1[w] = agauss(mux_m1w, 18n, 3)
  alter @m.xdut.xfa4_1.xmux1.m1[l] = agauss(mux_m1l, 18n, 3)
  alter @m.xdut.xfa4_1.xmux1.m2[w] = agauss(mux_m2w, 18n, 3)
  alter @m.xdut.xfa4_1.xmux1.m2[l] = agauss(mux_m2l, 18n, 3)
  alter @m.xdut.xfa4_1.xmux1.m3[w] = agauss(mux_m3w, 18n, 3)
  alter @m.xdut.xfa4_1.xmux1.m3[l] = agauss(mux_m3l, 18n, 3)
  alter @m.xdut.xfa4_1.xmux1.m4[w] = agauss(mux_m4w, 18n, 3)
  alter @m.xdut.xfa4_1.xmux1.m4[l] = agauss(mux_m4l, 18n, 3)
  alter @m.xdut.xfa4_1.xmux1.m5[w] = agauss(mux_m5w, 18n, 3)
  alter @m.xdut.xfa4_1.xmux1.m5[l] = agauss(mux_m5l, 18n, 3)
  alter @m.xdut.xfa4_1.xmux1.m6[w] = agauss(mux_m6w, 18n, 3)
  alter @m.xdut.xfa4_1.xmux1.m6[l] = agauss(mux_m6l, 18n, 3)
  alter @m.xdut.xfa4_1.xmux1.m7[w] = agauss(mux_m7w, 18n, 3)
  alter @m.xdut.xfa4_1.xmux1.m7[l] = agauss(mux_m7l, 18n, 3)
  alter @m.xdut.xfa4_1.xmux1.m8[w] = agauss(mux_m8w, 18n, 3)
  alter @m.xdut.xfa4_1.xmux1.m8[l] = agauss(mux_m8l, 18n, 3)
  alter @m.xdut.xfa4_1.xmux1.m9[w] = agauss(mux_m9w, 18n, 3)
  alter @m.xdut.xfa4_1.xmux1.m9[l] = agauss(mux_m9l, 18n, 3)
  alter @m.xdut.xfa5_0.xxor1.m0[w] = agauss(xor_m0w, 18n, 3)
  alter @m.xdut.xfa5_0.xxor1.m0[l] = agauss(xor_m0l, 18n, 3)
  alter @m.xdut.xfa5_0.xxor1.m1[w] = agauss(xor_m1w, 18n, 3)
  alter @m.xdut.xfa5_0.xxor1.m1[l] = agauss(xor_m1l, 18n, 3)
  alter @m.xdut.xfa5_0.xxor1.m2[w] = agauss(xor_m2w, 18n, 3)
  alter @m.xdut.xfa5_0.xxor1.m2[l] = agauss(xor_m2l, 18n, 3)
  alter @m.xdut.xfa5_0.xxor1.m3[w] = agauss(xor_m3w, 18n, 3)
  alter @m.xdut.xfa5_0.xxor1.m3[l] = agauss(xor_m3l, 18n, 3)
  alter @m.xdut.xfa5_0.xxor1.m4[w] = agauss(xor_m4w, 18n, 3)
  alter @m.xdut.xfa5_0.xxor1.m4[l] = agauss(xor_m4l, 18n, 3)
  alter @m.xdut.xfa5_0.xxor1.m5[w] = agauss(xor_m5w, 18n, 3)
  alter @m.xdut.xfa5_0.xxor1.m5[l] = agauss(xor_m5l, 18n, 3)
  alter @m.xdut.xfa5_0.xxor1.m6[w] = agauss(xor_m6w, 18n, 3)
  alter @m.xdut.xfa5_0.xxor1.m6[l] = agauss(xor_m6l, 18n, 3)
  alter @m.xdut.xfa5_0.xxor1.m7[w] = agauss(xor_m7w, 18n, 3)
  alter @m.xdut.xfa5_0.xxor1.m7[l] = agauss(xor_m7l, 18n, 3)
  alter @m.xdut.xfa5_0.xxor1.m8[w] = agauss(xor_m8w, 18n, 3)
  alter @m.xdut.xfa5_0.xxor1.m8[l] = agauss(xor_m8l, 18n, 3)
  alter @m.xdut.xfa5_0.xxor1.m9[w] = agauss(xor_m9w, 18n, 3)
  alter @m.xdut.xfa5_0.xxor1.m9[l] = agauss(xor_m9l, 18n, 3)
  alter @m.xdut.xfa5_0.xxor2.m0[w] = agauss(xor_m0w, 18n, 3)
  alter @m.xdut.xfa5_0.xxor2.m0[l] = agauss(xor_m0l, 18n, 3)
  alter @m.xdut.xfa5_0.xxor2.m1[w] = agauss(xor_m1w, 18n, 3)
  alter @m.xdut.xfa5_0.xxor2.m1[l] = agauss(xor_m1l, 18n, 3)
  alter @m.xdut.xfa5_0.xxor2.m2[w] = agauss(xor_m2w, 18n, 3)
  alter @m.xdut.xfa5_0.xxor2.m2[l] = agauss(xor_m2l, 18n, 3)
  alter @m.xdut.xfa5_0.xxor2.m3[w] = agauss(xor_m3w, 18n, 3)
  alter @m.xdut.xfa5_0.xxor2.m3[l] = agauss(xor_m3l, 18n, 3)
  alter @m.xdut.xfa5_0.xxor2.m4[w] = agauss(xor_m4w, 18n, 3)
  alter @m.xdut.xfa5_0.xxor2.m4[l] = agauss(xor_m4l, 18n, 3)
  alter @m.xdut.xfa5_0.xxor2.m5[w] = agauss(xor_m5w, 18n, 3)
  alter @m.xdut.xfa5_0.xxor2.m5[l] = agauss(xor_m5l, 18n, 3)
  alter @m.xdut.xfa5_0.xxor2.m6[w] = agauss(xor_m6w, 18n, 3)
  alter @m.xdut.xfa5_0.xxor2.m6[l] = agauss(xor_m6l, 18n, 3)
  alter @m.xdut.xfa5_0.xxor2.m7[w] = agauss(xor_m7w, 18n, 3)
  alter @m.xdut.xfa5_0.xxor2.m7[l] = agauss(xor_m7l, 18n, 3)
  alter @m.xdut.xfa5_0.xxor2.m8[w] = agauss(xor_m8w, 18n, 3)
  alter @m.xdut.xfa5_0.xxor2.m8[l] = agauss(xor_m8l, 18n, 3)
  alter @m.xdut.xfa5_0.xxor2.m9[w] = agauss(xor_m9w, 18n, 3)
  alter @m.xdut.xfa5_0.xxor2.m9[l] = agauss(xor_m9l, 18n, 3)
  alter @m.xdut.xfa5_0.xmux1.mo0[w] = agauss(mux_mo0w, 18n, 3)
  alter @m.xdut.xfa5_0.xmux1.mo0[l] = agauss(mux_mo0l, 18n, 3)
  alter @m.xdut.xfa5_0.xmux1.mo1[w] = agauss(mux_mo1w, 18n, 3)
  alter @m.xdut.xfa5_0.xmux1.mo1[l] = agauss(mux_mo1l, 18n, 3)
  alter @m.xdut.xfa5_0.xmux1.m0[w] = agauss(mux_m0w, 18n, 3)
  alter @m.xdut.xfa5_0.xmux1.m0[l] = agauss(mux_m0l, 18n, 3)
  alter @m.xdut.xfa5_0.xmux1.m1[w] = agauss(mux_m1w, 18n, 3)
  alter @m.xdut.xfa5_0.xmux1.m1[l] = agauss(mux_m1l, 18n, 3)
  alter @m.xdut.xfa5_0.xmux1.m2[w] = agauss(mux_m2w, 18n, 3)
  alter @m.xdut.xfa5_0.xmux1.m2[l] = agauss(mux_m2l, 18n, 3)
  alter @m.xdut.xfa5_0.xmux1.m3[w] = agauss(mux_m3w, 18n, 3)
  alter @m.xdut.xfa5_0.xmux1.m3[l] = agauss(mux_m3l, 18n, 3)
  alter @m.xdut.xfa5_0.xmux1.m4[w] = agauss(mux_m4w, 18n, 3)
  alter @m.xdut.xfa5_0.xmux1.m4[l] = agauss(mux_m4l, 18n, 3)
  alter @m.xdut.xfa5_0.xmux1.m5[w] = agauss(mux_m5w, 18n, 3)
  alter @m.xdut.xfa5_0.xmux1.m5[l] = agauss(mux_m5l, 18n, 3)
  alter @m.xdut.xfa5_0.xmux1.m6[w] = agauss(mux_m6w, 18n, 3)
  alter @m.xdut.xfa5_0.xmux1.m6[l] = agauss(mux_m6l, 18n, 3)
  alter @m.xdut.xfa5_0.xmux1.m7[w] = agauss(mux_m7w, 18n, 3)
  alter @m.xdut.xfa5_0.xmux1.m7[l] = agauss(mux_m7l, 18n, 3)
  alter @m.xdut.xfa5_0.xmux1.m8[w] = agauss(mux_m8w, 18n, 3)
  alter @m.xdut.xfa5_0.xmux1.m8[l] = agauss(mux_m8l, 18n, 3)
  alter @m.xdut.xfa5_0.xmux1.m9[w] = agauss(mux_m9w, 18n, 3)
  alter @m.xdut.xfa5_0.xmux1.m9[l] = agauss(mux_m9l, 18n, 3)
  alter @m.xdut.xfa5_1.xxor1.m0[w] = agauss(xor_m0w, 18n, 3)
  alter @m.xdut.xfa5_1.xxor1.m0[l] = agauss(xor_m0l, 18n, 3)
  alter @m.xdut.xfa5_1.xxor1.m1[w] = agauss(xor_m1w, 18n, 3)
  alter @m.xdut.xfa5_1.xxor1.m1[l] = agauss(xor_m1l, 18n, 3)
  alter @m.xdut.xfa5_1.xxor1.m2[w] = agauss(xor_m2w, 18n, 3)
  alter @m.xdut.xfa5_1.xxor1.m2[l] = agauss(xor_m2l, 18n, 3)
  alter @m.xdut.xfa5_1.xxor1.m3[w] = agauss(xor_m3w, 18n, 3)
  alter @m.xdut.xfa5_1.xxor1.m3[l] = agauss(xor_m3l, 18n, 3)
  alter @m.xdut.xfa5_1.xxor1.m4[w] = agauss(xor_m4w, 18n, 3)
  alter @m.xdut.xfa5_1.xxor1.m4[l] = agauss(xor_m4l, 18n, 3)
  alter @m.xdut.xfa5_1.xxor1.m5[w] = agauss(xor_m5w, 18n, 3)
  alter @m.xdut.xfa5_1.xxor1.m5[l] = agauss(xor_m5l, 18n, 3)
  alter @m.xdut.xfa5_1.xxor1.m6[w] = agauss(xor_m6w, 18n, 3)
  alter @m.xdut.xfa5_1.xxor1.m6[l] = agauss(xor_m6l, 18n, 3)
  alter @m.xdut.xfa5_1.xxor1.m7[w] = agauss(xor_m7w, 18n, 3)
  alter @m.xdut.xfa5_1.xxor1.m7[l] = agauss(xor_m7l, 18n, 3)
  alter @m.xdut.xfa5_1.xxor1.m8[w] = agauss(xor_m8w, 18n, 3)
  alter @m.xdut.xfa5_1.xxor1.m8[l] = agauss(xor_m8l, 18n, 3)
  alter @m.xdut.xfa5_1.xxor1.m9[w] = agauss(xor_m9w, 18n, 3)
  alter @m.xdut.xfa5_1.xxor1.m9[l] = agauss(xor_m9l, 18n, 3)
  alter @m.xdut.xfa5_1.xxor2.m0[w] = agauss(xor_m0w, 18n, 3)
  alter @m.xdut.xfa5_1.xxor2.m0[l] = agauss(xor_m0l, 18n, 3)
  alter @m.xdut.xfa5_1.xxor2.m1[w] = agauss(xor_m1w, 18n, 3)
  alter @m.xdut.xfa5_1.xxor2.m1[l] = agauss(xor_m1l, 18n, 3)
  alter @m.xdut.xfa5_1.xxor2.m2[w] = agauss(xor_m2w, 18n, 3)
  alter @m.xdut.xfa5_1.xxor2.m2[l] = agauss(xor_m2l, 18n, 3)
  alter @m.xdut.xfa5_1.xxor2.m3[w] = agauss(xor_m3w, 18n, 3)
  alter @m.xdut.xfa5_1.xxor2.m3[l] = agauss(xor_m3l, 18n, 3)
  alter @m.xdut.xfa5_1.xxor2.m4[w] = agauss(xor_m4w, 18n, 3)
  alter @m.xdut.xfa5_1.xxor2.m4[l] = agauss(xor_m4l, 18n, 3)
  alter @m.xdut.xfa5_1.xxor2.m5[w] = agauss(xor_m5w, 18n, 3)
  alter @m.xdut.xfa5_1.xxor2.m5[l] = agauss(xor_m5l, 18n, 3)
  alter @m.xdut.xfa5_1.xxor2.m6[w] = agauss(xor_m6w, 18n, 3)
  alter @m.xdut.xfa5_1.xxor2.m6[l] = agauss(xor_m6l, 18n, 3)
  alter @m.xdut.xfa5_1.xxor2.m7[w] = agauss(xor_m7w, 18n, 3)
  alter @m.xdut.xfa5_1.xxor2.m7[l] = agauss(xor_m7l, 18n, 3)
  alter @m.xdut.xfa5_1.xxor2.m8[w] = agauss(xor_m8w, 18n, 3)
  alter @m.xdut.xfa5_1.xxor2.m8[l] = agauss(xor_m8l, 18n, 3)
  alter @m.xdut.xfa5_1.xxor2.m9[w] = agauss(xor_m9w, 18n, 3)
  alter @m.xdut.xfa5_1.xxor2.m9[l] = agauss(xor_m9l, 18n, 3)
  alter @m.xdut.xfa5_1.xmux1.mo0[w] = agauss(mux_mo0w, 18n, 3)
  alter @m.xdut.xfa5_1.xmux1.mo0[l] = agauss(mux_mo0l, 18n, 3)
  alter @m.xdut.xfa5_1.xmux1.mo1[w] = agauss(mux_mo1w, 18n, 3)
  alter @m.xdut.xfa5_1.xmux1.mo1[l] = agauss(mux_mo1l, 18n, 3)
  alter @m.xdut.xfa5_1.xmux1.m0[w] = agauss(mux_m0w, 18n, 3)
  alter @m.xdut.xfa5_1.xmux1.m0[l] = agauss(mux_m0l, 18n, 3)
  alter @m.xdut.xfa5_1.xmux1.m1[w] = agauss(mux_m1w, 18n, 3)
  alter @m.xdut.xfa5_1.xmux1.m1[l] = agauss(mux_m1l, 18n, 3)
  alter @m.xdut.xfa5_1.xmux1.m2[w] = agauss(mux_m2w, 18n, 3)
  alter @m.xdut.xfa5_1.xmux1.m2[l] = agauss(mux_m2l, 18n, 3)
  alter @m.xdut.xfa5_1.xmux1.m3[w] = agauss(mux_m3w, 18n, 3)
  alter @m.xdut.xfa5_1.xmux1.m3[l] = agauss(mux_m3l, 18n, 3)
  alter @m.xdut.xfa5_1.xmux1.m4[w] = agauss(mux_m4w, 18n, 3)
  alter @m.xdut.xfa5_1.xmux1.m4[l] = agauss(mux_m4l, 18n, 3)
  alter @m.xdut.xfa5_1.xmux1.m5[w] = agauss(mux_m5w, 18n, 3)
  alter @m.xdut.xfa5_1.xmux1.m5[l] = agauss(mux_m5l, 18n, 3)
  alter @m.xdut.xfa5_1.xmux1.m6[w] = agauss(mux_m6w, 18n, 3)
  alter @m.xdut.xfa5_1.xmux1.m6[l] = agauss(mux_m6l, 18n, 3)
  alter @m.xdut.xfa5_1.xmux1.m7[w] = agauss(mux_m7w, 18n, 3)
  alter @m.xdut.xfa5_1.xmux1.m7[l] = agauss(mux_m7l, 18n, 3)
  alter @m.xdut.xfa5_1.xmux1.m8[w] = agauss(mux_m8w, 18n, 3)
  alter @m.xdut.xfa5_1.xmux1.m8[l] = agauss(mux_m8l, 18n, 3)
  alter @m.xdut.xfa5_1.xmux1.m9[w] = agauss(mux_m9w, 18n, 3)
  alter @m.xdut.xfa5_1.xmux1.m9[l] = agauss(mux_m9l, 18n, 3)
  alter @m.xdut.xfa6_0.xxor1.m0[w] = agauss(xor_m0w, 18n, 3)
  alter @m.xdut.xfa6_0.xxor1.m0[l] = agauss(xor_m0l, 18n, 3)
  alter @m.xdut.xfa6_0.xxor1.m1[w] = agauss(xor_m1w, 18n, 3)
  alter @m.xdut.xfa6_0.xxor1.m1[l] = agauss(xor_m1l, 18n, 3)
  alter @m.xdut.xfa6_0.xxor1.m2[w] = agauss(xor_m2w, 18n, 3)
  alter @m.xdut.xfa6_0.xxor1.m2[l] = agauss(xor_m2l, 18n, 3)
  alter @m.xdut.xfa6_0.xxor1.m3[w] = agauss(xor_m3w, 18n, 3)
  alter @m.xdut.xfa6_0.xxor1.m3[l] = agauss(xor_m3l, 18n, 3)
  alter @m.xdut.xfa6_0.xxor1.m4[w] = agauss(xor_m4w, 18n, 3)
  alter @m.xdut.xfa6_0.xxor1.m4[l] = agauss(xor_m4l, 18n, 3)
  alter @m.xdut.xfa6_0.xxor1.m5[w] = agauss(xor_m5w, 18n, 3)
  alter @m.xdut.xfa6_0.xxor1.m5[l] = agauss(xor_m5l, 18n, 3)
  alter @m.xdut.xfa6_0.xxor1.m6[w] = agauss(xor_m6w, 18n, 3)
  alter @m.xdut.xfa6_0.xxor1.m6[l] = agauss(xor_m6l, 18n, 3)
  alter @m.xdut.xfa6_0.xxor1.m7[w] = agauss(xor_m7w, 18n, 3)
  alter @m.xdut.xfa6_0.xxor1.m7[l] = agauss(xor_m7l, 18n, 3)
  alter @m.xdut.xfa6_0.xxor1.m8[w] = agauss(xor_m8w, 18n, 3)
  alter @m.xdut.xfa6_0.xxor1.m8[l] = agauss(xor_m8l, 18n, 3)
  alter @m.xdut.xfa6_0.xxor1.m9[w] = agauss(xor_m9w, 18n, 3)
  alter @m.xdut.xfa6_0.xxor1.m9[l] = agauss(xor_m9l, 18n, 3)
  alter @m.xdut.xfa6_0.xxor2.m0[w] = agauss(xor_m0w, 18n, 3)
  alter @m.xdut.xfa6_0.xxor2.m0[l] = agauss(xor_m0l, 18n, 3)
  alter @m.xdut.xfa6_0.xxor2.m1[w] = agauss(xor_m1w, 18n, 3)
  alter @m.xdut.xfa6_0.xxor2.m1[l] = agauss(xor_m1l, 18n, 3)
  alter @m.xdut.xfa6_0.xxor2.m2[w] = agauss(xor_m2w, 18n, 3)
  alter @m.xdut.xfa6_0.xxor2.m2[l] = agauss(xor_m2l, 18n, 3)
  alter @m.xdut.xfa6_0.xxor2.m3[w] = agauss(xor_m3w, 18n, 3)
  alter @m.xdut.xfa6_0.xxor2.m3[l] = agauss(xor_m3l, 18n, 3)
  alter @m.xdut.xfa6_0.xxor2.m4[w] = agauss(xor_m4w, 18n, 3)
  alter @m.xdut.xfa6_0.xxor2.m4[l] = agauss(xor_m4l, 18n, 3)
  alter @m.xdut.xfa6_0.xxor2.m5[w] = agauss(xor_m5w, 18n, 3)
  alter @m.xdut.xfa6_0.xxor2.m5[l] = agauss(xor_m5l, 18n, 3)
  alter @m.xdut.xfa6_0.xxor2.m6[w] = agauss(xor_m6w, 18n, 3)
  alter @m.xdut.xfa6_0.xxor2.m6[l] = agauss(xor_m6l, 18n, 3)
  alter @m.xdut.xfa6_0.xxor2.m7[w] = agauss(xor_m7w, 18n, 3)
  alter @m.xdut.xfa6_0.xxor2.m7[l] = agauss(xor_m7l, 18n, 3)
  alter @m.xdut.xfa6_0.xxor2.m8[w] = agauss(xor_m8w, 18n, 3)
  alter @m.xdut.xfa6_0.xxor2.m8[l] = agauss(xor_m8l, 18n, 3)
  alter @m.xdut.xfa6_0.xxor2.m9[w] = agauss(xor_m9w, 18n, 3)
  alter @m.xdut.xfa6_0.xxor2.m9[l] = agauss(xor_m9l, 18n, 3)
  alter @m.xdut.xfa6_0.xmux1.mo0[w] = agauss(mux_mo0w, 18n, 3)
  alter @m.xdut.xfa6_0.xmux1.mo0[l] = agauss(mux_mo0l, 18n, 3)
  alter @m.xdut.xfa6_0.xmux1.mo1[w] = agauss(mux_mo1w, 18n, 3)
  alter @m.xdut.xfa6_0.xmux1.mo1[l] = agauss(mux_mo1l, 18n, 3)
  alter @m.xdut.xfa6_0.xmux1.m0[w] = agauss(mux_m0w, 18n, 3)
  alter @m.xdut.xfa6_0.xmux1.m0[l] = agauss(mux_m0l, 18n, 3)
  alter @m.xdut.xfa6_0.xmux1.m1[w] = agauss(mux_m1w, 18n, 3)
  alter @m.xdut.xfa6_0.xmux1.m1[l] = agauss(mux_m1l, 18n, 3)
  alter @m.xdut.xfa6_0.xmux1.m2[w] = agauss(mux_m2w, 18n, 3)
  alter @m.xdut.xfa6_0.xmux1.m2[l] = agauss(mux_m2l, 18n, 3)
  alter @m.xdut.xfa6_0.xmux1.m3[w] = agauss(mux_m3w, 18n, 3)
  alter @m.xdut.xfa6_0.xmux1.m3[l] = agauss(mux_m3l, 18n, 3)
  alter @m.xdut.xfa6_0.xmux1.m4[w] = agauss(mux_m4w, 18n, 3)
  alter @m.xdut.xfa6_0.xmux1.m4[l] = agauss(mux_m4l, 18n, 3)
  alter @m.xdut.xfa6_0.xmux1.m5[w] = agauss(mux_m5w, 18n, 3)
  alter @m.xdut.xfa6_0.xmux1.m5[l] = agauss(mux_m5l, 18n, 3)
  alter @m.xdut.xfa6_0.xmux1.m6[w] = agauss(mux_m6w, 18n, 3)
  alter @m.xdut.xfa6_0.xmux1.m6[l] = agauss(mux_m6l, 18n, 3)
  alter @m.xdut.xfa6_0.xmux1.m7[w] = agauss(mux_m7w, 18n, 3)
  alter @m.xdut.xfa6_0.xmux1.m7[l] = agauss(mux_m7l, 18n, 3)
  alter @m.xdut.xfa6_0.xmux1.m8[w] = agauss(mux_m8w, 18n, 3)
  alter @m.xdut.xfa6_0.xmux1.m8[l] = agauss(mux_m8l, 18n, 3)
  alter @m.xdut.xfa6_0.xmux1.m9[w] = agauss(mux_m9w, 18n, 3)
  alter @m.xdut.xfa6_0.xmux1.m9[l] = agauss(mux_m9l, 18n, 3)
  alter @m.xdut.xfa6_1.xxor1.m0[w] = agauss(xor_m0w, 18n, 3)
  alter @m.xdut.xfa6_1.xxor1.m0[l] = agauss(xor_m0l, 18n, 3)
  alter @m.xdut.xfa6_1.xxor1.m1[w] = agauss(xor_m1w, 18n, 3)
  alter @m.xdut.xfa6_1.xxor1.m1[l] = agauss(xor_m1l, 18n, 3)
  alter @m.xdut.xfa6_1.xxor1.m2[w] = agauss(xor_m2w, 18n, 3)
  alter @m.xdut.xfa6_1.xxor1.m2[l] = agauss(xor_m2l, 18n, 3)
  alter @m.xdut.xfa6_1.xxor1.m3[w] = agauss(xor_m3w, 18n, 3)
  alter @m.xdut.xfa6_1.xxor1.m3[l] = agauss(xor_m3l, 18n, 3)
  alter @m.xdut.xfa6_1.xxor1.m4[w] = agauss(xor_m4w, 18n, 3)
  alter @m.xdut.xfa6_1.xxor1.m4[l] = agauss(xor_m4l, 18n, 3)
  alter @m.xdut.xfa6_1.xxor1.m5[w] = agauss(xor_m5w, 18n, 3)
  alter @m.xdut.xfa6_1.xxor1.m5[l] = agauss(xor_m5l, 18n, 3)
  alter @m.xdut.xfa6_1.xxor1.m6[w] = agauss(xor_m6w, 18n, 3)
  alter @m.xdut.xfa6_1.xxor1.m6[l] = agauss(xor_m6l, 18n, 3)
  alter @m.xdut.xfa6_1.xxor1.m7[w] = agauss(xor_m7w, 18n, 3)
  alter @m.xdut.xfa6_1.xxor1.m7[l] = agauss(xor_m7l, 18n, 3)
  alter @m.xdut.xfa6_1.xxor1.m8[w] = agauss(xor_m8w, 18n, 3)
  alter @m.xdut.xfa6_1.xxor1.m8[l] = agauss(xor_m8l, 18n, 3)
  alter @m.xdut.xfa6_1.xxor1.m9[w] = agauss(xor_m9w, 18n, 3)
  alter @m.xdut.xfa6_1.xxor1.m9[l] = agauss(xor_m9l, 18n, 3)
  alter @m.xdut.xfa6_1.xxor2.m0[w] = agauss(xor_m0w, 18n, 3)
  alter @m.xdut.xfa6_1.xxor2.m0[l] = agauss(xor_m0l, 18n, 3)
  alter @m.xdut.xfa6_1.xxor2.m1[w] = agauss(xor_m1w, 18n, 3)
  alter @m.xdut.xfa6_1.xxor2.m1[l] = agauss(xor_m1l, 18n, 3)
  alter @m.xdut.xfa6_1.xxor2.m2[w] = agauss(xor_m2w, 18n, 3)
  alter @m.xdut.xfa6_1.xxor2.m2[l] = agauss(xor_m2l, 18n, 3)
  alter @m.xdut.xfa6_1.xxor2.m3[w] = agauss(xor_m3w, 18n, 3)
  alter @m.xdut.xfa6_1.xxor2.m3[l] = agauss(xor_m3l, 18n, 3)
  alter @m.xdut.xfa6_1.xxor2.m4[w] = agauss(xor_m4w, 18n, 3)
  alter @m.xdut.xfa6_1.xxor2.m4[l] = agauss(xor_m4l, 18n, 3)
  alter @m.xdut.xfa6_1.xxor2.m5[w] = agauss(xor_m5w, 18n, 3)
  alter @m.xdut.xfa6_1.xxor2.m5[l] = agauss(xor_m5l, 18n, 3)
  alter @m.xdut.xfa6_1.xxor2.m6[w] = agauss(xor_m6w, 18n, 3)
  alter @m.xdut.xfa6_1.xxor2.m6[l] = agauss(xor_m6l, 18n, 3)
  alter @m.xdut.xfa6_1.xxor2.m7[w] = agauss(xor_m7w, 18n, 3)
  alter @m.xdut.xfa6_1.xxor2.m7[l] = agauss(xor_m7l, 18n, 3)
  alter @m.xdut.xfa6_1.xxor2.m8[w] = agauss(xor_m8w, 18n, 3)
  alter @m.xdut.xfa6_1.xxor2.m8[l] = agauss(xor_m8l, 18n, 3)
  alter @m.xdut.xfa6_1.xxor2.m9[w] = agauss(xor_m9w, 18n, 3)
  alter @m.xdut.xfa6_1.xxor2.m9[l] = agauss(xor_m9l, 18n, 3)
  alter @m.xdut.xfa6_1.xmux1.mo0[w] = agauss(mux_mo0w, 18n, 3)
  alter @m.xdut.xfa6_1.xmux1.mo0[l] = agauss(mux_mo0l, 18n, 3)
  alter @m.xdut.xfa6_1.xmux1.mo1[w] = agauss(mux_mo1w, 18n, 3)
  alter @m.xdut.xfa6_1.xmux1.mo1[l] = agauss(mux_mo1l, 18n, 3)
  alter @m.xdut.xfa6_1.xmux1.m0[w] = agauss(mux_m0w, 18n, 3)
  alter @m.xdut.xfa6_1.xmux1.m0[l] = agauss(mux_m0l, 18n, 3)
  alter @m.xdut.xfa6_1.xmux1.m1[w] = agauss(mux_m1w, 18n, 3)
  alter @m.xdut.xfa6_1.xmux1.m1[l] = agauss(mux_m1l, 18n, 3)
  alter @m.xdut.xfa6_1.xmux1.m2[w] = agauss(mux_m2w, 18n, 3)
  alter @m.xdut.xfa6_1.xmux1.m2[l] = agauss(mux_m2l, 18n, 3)
  alter @m.xdut.xfa6_1.xmux1.m3[w] = agauss(mux_m3w, 18n, 3)
  alter @m.xdut.xfa6_1.xmux1.m3[l] = agauss(mux_m3l, 18n, 3)
  alter @m.xdut.xfa6_1.xmux1.m4[w] = agauss(mux_m4w, 18n, 3)
  alter @m.xdut.xfa6_1.xmux1.m4[l] = agauss(mux_m4l, 18n, 3)
  alter @m.xdut.xfa6_1.xmux1.m5[w] = agauss(mux_m5w, 18n, 3)
  alter @m.xdut.xfa6_1.xmux1.m5[l] = agauss(mux_m5l, 18n, 3)
  alter @m.xdut.xfa6_1.xmux1.m6[w] = agauss(mux_m6w, 18n, 3)
  alter @m.xdut.xfa6_1.xmux1.m6[l] = agauss(mux_m6l, 18n, 3)
  alter @m.xdut.xfa6_1.xmux1.m7[w] = agauss(mux_m7w, 18n, 3)
  alter @m.xdut.xfa6_1.xmux1.m7[l] = agauss(mux_m7l, 18n, 3)
  alter @m.xdut.xfa6_1.xmux1.m8[w] = agauss(mux_m8w, 18n, 3)
  alter @m.xdut.xfa6_1.xmux1.m8[l] = agauss(mux_m8l, 18n, 3)
  alter @m.xdut.xfa6_1.xmux1.m9[w] = agauss(mux_m9w, 18n, 3)
  alter @m.xdut.xfa6_1.xmux1.m9[l] = agauss(mux_m9l, 18n, 3)
  alter @m.xdut.xfa7_0.xxor1.m0[w] = agauss(xor_m0w, 18n, 3)
  alter @m.xdut.xfa7_0.xxor1.m0[l] = agauss(xor_m0l, 18n, 3)
  alter @m.xdut.xfa7_0.xxor1.m1[w] = agauss(xor_m1w, 18n, 3)
  alter @m.xdut.xfa7_0.xxor1.m1[l] = agauss(xor_m1l, 18n, 3)
  alter @m.xdut.xfa7_0.xxor1.m2[w] = agauss(xor_m2w, 18n, 3)
  alter @m.xdut.xfa7_0.xxor1.m2[l] = agauss(xor_m2l, 18n, 3)
  alter @m.xdut.xfa7_0.xxor1.m3[w] = agauss(xor_m3w, 18n, 3)
  alter @m.xdut.xfa7_0.xxor1.m3[l] = agauss(xor_m3l, 18n, 3)
  alter @m.xdut.xfa7_0.xxor1.m4[w] = agauss(xor_m4w, 18n, 3)
  alter @m.xdut.xfa7_0.xxor1.m4[l] = agauss(xor_m4l, 18n, 3)
  alter @m.xdut.xfa7_0.xxor1.m5[w] = agauss(xor_m5w, 18n, 3)
  alter @m.xdut.xfa7_0.xxor1.m5[l] = agauss(xor_m5l, 18n, 3)
  alter @m.xdut.xfa7_0.xxor1.m6[w] = agauss(xor_m6w, 18n, 3)
  alter @m.xdut.xfa7_0.xxor1.m6[l] = agauss(xor_m6l, 18n, 3)
  alter @m.xdut.xfa7_0.xxor1.m7[w] = agauss(xor_m7w, 18n, 3)
  alter @m.xdut.xfa7_0.xxor1.m7[l] = agauss(xor_m7l, 18n, 3)
  alter @m.xdut.xfa7_0.xxor1.m8[w] = agauss(xor_m8w, 18n, 3)
  alter @m.xdut.xfa7_0.xxor1.m8[l] = agauss(xor_m8l, 18n, 3)
  alter @m.xdut.xfa7_0.xxor1.m9[w] = agauss(xor_m9w, 18n, 3)
  alter @m.xdut.xfa7_0.xxor1.m9[l] = agauss(xor_m9l, 18n, 3)
  alter @m.xdut.xfa7_0.xxor2.m0[w] = agauss(xor_m0w, 18n, 3)
  alter @m.xdut.xfa7_0.xxor2.m0[l] = agauss(xor_m0l, 18n, 3)
  alter @m.xdut.xfa7_0.xxor2.m1[w] = agauss(xor_m1w, 18n, 3)
  alter @m.xdut.xfa7_0.xxor2.m1[l] = agauss(xor_m1l, 18n, 3)
  alter @m.xdut.xfa7_0.xxor2.m2[w] = agauss(xor_m2w, 18n, 3)
  alter @m.xdut.xfa7_0.xxor2.m2[l] = agauss(xor_m2l, 18n, 3)
  alter @m.xdut.xfa7_0.xxor2.m3[w] = agauss(xor_m3w, 18n, 3)
  alter @m.xdut.xfa7_0.xxor2.m3[l] = agauss(xor_m3l, 18n, 3)
  alter @m.xdut.xfa7_0.xxor2.m4[w] = agauss(xor_m4w, 18n, 3)
  alter @m.xdut.xfa7_0.xxor2.m4[l] = agauss(xor_m4l, 18n, 3)
  alter @m.xdut.xfa7_0.xxor2.m5[w] = agauss(xor_m5w, 18n, 3)
  alter @m.xdut.xfa7_0.xxor2.m5[l] = agauss(xor_m5l, 18n, 3)
  alter @m.xdut.xfa7_0.xxor2.m6[w] = agauss(xor_m6w, 18n, 3)
  alter @m.xdut.xfa7_0.xxor2.m6[l] = agauss(xor_m6l, 18n, 3)
  alter @m.xdut.xfa7_0.xxor2.m7[w] = agauss(xor_m7w, 18n, 3)
  alter @m.xdut.xfa7_0.xxor2.m7[l] = agauss(xor_m7l, 18n, 3)
  alter @m.xdut.xfa7_0.xxor2.m8[w] = agauss(xor_m8w, 18n, 3)
  alter @m.xdut.xfa7_0.xxor2.m8[l] = agauss(xor_m8l, 18n, 3)
  alter @m.xdut.xfa7_0.xxor2.m9[w] = agauss(xor_m9w, 18n, 3)
  alter @m.xdut.xfa7_0.xxor2.m9[l] = agauss(xor_m9l, 18n, 3)
  alter @m.xdut.xfa7_0.xmux1.mo0[w] = agauss(mux_mo0w, 18n, 3)
  alter @m.xdut.xfa7_0.xmux1.mo0[l] = agauss(mux_mo0l, 18n, 3)
  alter @m.xdut.xfa7_0.xmux1.mo1[w] = agauss(mux_mo1w, 18n, 3)
  alter @m.xdut.xfa7_0.xmux1.mo1[l] = agauss(mux_mo1l, 18n, 3)
  alter @m.xdut.xfa7_0.xmux1.m0[w] = agauss(mux_m0w, 18n, 3)
  alter @m.xdut.xfa7_0.xmux1.m0[l] = agauss(mux_m0l, 18n, 3)
  alter @m.xdut.xfa7_0.xmux1.m1[w] = agauss(mux_m1w, 18n, 3)
  alter @m.xdut.xfa7_0.xmux1.m1[l] = agauss(mux_m1l, 18n, 3)
  alter @m.xdut.xfa7_0.xmux1.m2[w] = agauss(mux_m2w, 18n, 3)
  alter @m.xdut.xfa7_0.xmux1.m2[l] = agauss(mux_m2l, 18n, 3)
  alter @m.xdut.xfa7_0.xmux1.m3[w] = agauss(mux_m3w, 18n, 3)
  alter @m.xdut.xfa7_0.xmux1.m3[l] = agauss(mux_m3l, 18n, 3)
  alter @m.xdut.xfa7_0.xmux1.m4[w] = agauss(mux_m4w, 18n, 3)
  alter @m.xdut.xfa7_0.xmux1.m4[l] = agauss(mux_m4l, 18n, 3)
  alter @m.xdut.xfa7_0.xmux1.m5[w] = agauss(mux_m5w, 18n, 3)
  alter @m.xdut.xfa7_0.xmux1.m5[l] = agauss(mux_m5l, 18n, 3)
  alter @m.xdut.xfa7_0.xmux1.m6[w] = agauss(mux_m6w, 18n, 3)
  alter @m.xdut.xfa7_0.xmux1.m6[l] = agauss(mux_m6l, 18n, 3)
  alter @m.xdut.xfa7_0.xmux1.m7[w] = agauss(mux_m7w, 18n, 3)
  alter @m.xdut.xfa7_0.xmux1.m7[l] = agauss(mux_m7l, 18n, 3)
  alter @m.xdut.xfa7_0.xmux1.m8[w] = agauss(mux_m8w, 18n, 3)
  alter @m.xdut.xfa7_0.xmux1.m8[l] = agauss(mux_m8l, 18n, 3)
  alter @m.xdut.xfa7_0.xmux1.m9[w] = agauss(mux_m9w, 18n, 3)
  alter @m.xdut.xfa7_0.xmux1.m9[l] = agauss(mux_m9l, 18n, 3)
  alter @m.xdut.xfa7_1.xxor1.m0[w] = agauss(xor_m0w, 18n, 3)
  alter @m.xdut.xfa7_1.xxor1.m0[l] = agauss(xor_m0l, 18n, 3)
  alter @m.xdut.xfa7_1.xxor1.m1[w] = agauss(xor_m1w, 18n, 3)
  alter @m.xdut.xfa7_1.xxor1.m1[l] = agauss(xor_m1l, 18n, 3)
  alter @m.xdut.xfa7_1.xxor1.m2[w] = agauss(xor_m2w, 18n, 3)
  alter @m.xdut.xfa7_1.xxor1.m2[l] = agauss(xor_m2l, 18n, 3)
  alter @m.xdut.xfa7_1.xxor1.m3[w] = agauss(xor_m3w, 18n, 3)
  alter @m.xdut.xfa7_1.xxor1.m3[l] = agauss(xor_m3l, 18n, 3)
  alter @m.xdut.xfa7_1.xxor1.m4[w] = agauss(xor_m4w, 18n, 3)
  alter @m.xdut.xfa7_1.xxor1.m4[l] = agauss(xor_m4l, 18n, 3)
  alter @m.xdut.xfa7_1.xxor1.m5[w] = agauss(xor_m5w, 18n, 3)
  alter @m.xdut.xfa7_1.xxor1.m5[l] = agauss(xor_m5l, 18n, 3)
  alter @m.xdut.xfa7_1.xxor1.m6[w] = agauss(xor_m6w, 18n, 3)
  alter @m.xdut.xfa7_1.xxor1.m6[l] = agauss(xor_m6l, 18n, 3)
  alter @m.xdut.xfa7_1.xxor1.m7[w] = agauss(xor_m7w, 18n, 3)
  alter @m.xdut.xfa7_1.xxor1.m7[l] = agauss(xor_m7l, 18n, 3)
  alter @m.xdut.xfa7_1.xxor1.m8[w] = agauss(xor_m8w, 18n, 3)
  alter @m.xdut.xfa7_1.xxor1.m8[l] = agauss(xor_m8l, 18n, 3)
  alter @m.xdut.xfa7_1.xxor1.m9[w] = agauss(xor_m9w, 18n, 3)
  alter @m.xdut.xfa7_1.xxor1.m9[l] = agauss(xor_m9l, 18n, 3)
  alter @m.xdut.xfa7_1.xxor2.m0[w] = agauss(xor_m0w, 18n, 3)
  alter @m.xdut.xfa7_1.xxor2.m0[l] = agauss(xor_m0l, 18n, 3)
  alter @m.xdut.xfa7_1.xxor2.m1[w] = agauss(xor_m1w, 18n, 3)
  alter @m.xdut.xfa7_1.xxor2.m1[l] = agauss(xor_m1l, 18n, 3)
  alter @m.xdut.xfa7_1.xxor2.m2[w] = agauss(xor_m2w, 18n, 3)
  alter @m.xdut.xfa7_1.xxor2.m2[l] = agauss(xor_m2l, 18n, 3)
  alter @m.xdut.xfa7_1.xxor2.m3[w] = agauss(xor_m3w, 18n, 3)
  alter @m.xdut.xfa7_1.xxor2.m3[l] = agauss(xor_m3l, 18n, 3)
  alter @m.xdut.xfa7_1.xxor2.m4[w] = agauss(xor_m4w, 18n, 3)
  alter @m.xdut.xfa7_1.xxor2.m4[l] = agauss(xor_m4l, 18n, 3)
  alter @m.xdut.xfa7_1.xxor2.m5[w] = agauss(xor_m5w, 18n, 3)
  alter @m.xdut.xfa7_1.xxor2.m5[l] = agauss(xor_m5l, 18n, 3)
  alter @m.xdut.xfa7_1.xxor2.m6[w] = agauss(xor_m6w, 18n, 3)
  alter @m.xdut.xfa7_1.xxor2.m6[l] = agauss(xor_m6l, 18n, 3)
  alter @m.xdut.xfa7_1.xxor2.m7[w] = agauss(xor_m7w, 18n, 3)
  alter @m.xdut.xfa7_1.xxor2.m7[l] = agauss(xor_m7l, 18n, 3)
  alter @m.xdut.xfa7_1.xxor2.m8[w] = agauss(xor_m8w, 18n, 3)
  alter @m.xdut.xfa7_1.xxor2.m8[l] = agauss(xor_m8l, 18n, 3)
  alter @m.xdut.xfa7_1.xxor2.m9[w] = agauss(xor_m9w, 18n, 3)
  alter @m.xdut.xfa7_1.xxor2.m9[l] = agauss(xor_m9l, 18n, 3)
  alter @m.xdut.xfa7_1.xmux1.mo0[w] = agauss(mux_mo0w, 18n, 3)
  alter @m.xdut.xfa7_1.xmux1.mo0[l] = agauss(mux_mo0l, 18n, 3)
  alter @m.xdut.xfa7_1.xmux1.mo1[w] = agauss(mux_mo1w, 18n, 3)
  alter @m.xdut.xfa7_1.xmux1.mo1[l] = agauss(mux_mo1l, 18n, 3)
  alter @m.xdut.xfa7_1.xmux1.m0[w] = agauss(mux_m0w, 18n, 3)
  alter @m.xdut.xfa7_1.xmux1.m0[l] = agauss(mux_m0l, 18n, 3)
  alter @m.xdut.xfa7_1.xmux1.m1[w] = agauss(mux_m1w, 18n, 3)
  alter @m.xdut.xfa7_1.xmux1.m1[l] = agauss(mux_m1l, 18n, 3)
  alter @m.xdut.xfa7_1.xmux1.m2[w] = agauss(mux_m2w, 18n, 3)
  alter @m.xdut.xfa7_1.xmux1.m2[l] = agauss(mux_m2l, 18n, 3)
  alter @m.xdut.xfa7_1.xmux1.m3[w] = agauss(mux_m3w, 18n, 3)
  alter @m.xdut.xfa7_1.xmux1.m3[l] = agauss(mux_m3l, 18n, 3)
  alter @m.xdut.xfa7_1.xmux1.m4[w] = agauss(mux_m4w, 18n, 3)
  alter @m.xdut.xfa7_1.xmux1.m4[l] = agauss(mux_m4l, 18n, 3)
  alter @m.xdut.xfa7_1.xmux1.m5[w] = agauss(mux_m5w, 18n, 3)
  alter @m.xdut.xfa7_1.xmux1.m5[l] = agauss(mux_m5l, 18n, 3)
  alter @m.xdut.xfa7_1.xmux1.m6[w] = agauss(mux_m6w, 18n, 3)
  alter @m.xdut.xfa7_1.xmux1.m6[l] = agauss(mux_m6l, 18n, 3)
  alter @m.xdut.xfa7_1.xmux1.m7[w] = agauss(mux_m7w, 18n, 3)
  alter @m.xdut.xfa7_1.xmux1.m7[l] = agauss(mux_m7l, 18n, 3)
  alter @m.xdut.xfa7_1.xmux1.m8[w] = agauss(mux_m8w, 18n, 3)
  alter @m.xdut.xfa7_1.xmux1.m8[l] = agauss(mux_m8l, 18n, 3)
  alter @m.xdut.xfa7_1.xmux1.m9[w] = agauss(mux_m9w, 18n, 3)
  alter @m.xdut.xfa7_1.xmux1.m9[l] = agauss(mux_m9l, 18n, 3)
  alter @m.xdut.xfa8_0.xxor1.m0[w] = agauss(xor_m0w, 18n, 3)
  alter @m.xdut.xfa8_0.xxor1.m0[l] = agauss(xor_m0l, 18n, 3)
  alter @m.xdut.xfa8_0.xxor1.m1[w] = agauss(xor_m1w, 18n, 3)
  alter @m.xdut.xfa8_0.xxor1.m1[l] = agauss(xor_m1l, 18n, 3)
  alter @m.xdut.xfa8_0.xxor1.m2[w] = agauss(xor_m2w, 18n, 3)
  alter @m.xdut.xfa8_0.xxor1.m2[l] = agauss(xor_m2l, 18n, 3)
  alter @m.xdut.xfa8_0.xxor1.m3[w] = agauss(xor_m3w, 18n, 3)
  alter @m.xdut.xfa8_0.xxor1.m3[l] = agauss(xor_m3l, 18n, 3)
  alter @m.xdut.xfa8_0.xxor1.m4[w] = agauss(xor_m4w, 18n, 3)
  alter @m.xdut.xfa8_0.xxor1.m4[l] = agauss(xor_m4l, 18n, 3)
  alter @m.xdut.xfa8_0.xxor1.m5[w] = agauss(xor_m5w, 18n, 3)
  alter @m.xdut.xfa8_0.xxor1.m5[l] = agauss(xor_m5l, 18n, 3)
  alter @m.xdut.xfa8_0.xxor1.m6[w] = agauss(xor_m6w, 18n, 3)
  alter @m.xdut.xfa8_0.xxor1.m6[l] = agauss(xor_m6l, 18n, 3)
  alter @m.xdut.xfa8_0.xxor1.m7[w] = agauss(xor_m7w, 18n, 3)
  alter @m.xdut.xfa8_0.xxor1.m7[l] = agauss(xor_m7l, 18n, 3)
  alter @m.xdut.xfa8_0.xxor1.m8[w] = agauss(xor_m8w, 18n, 3)
  alter @m.xdut.xfa8_0.xxor1.m8[l] = agauss(xor_m8l, 18n, 3)
  alter @m.xdut.xfa8_0.xxor1.m9[w] = agauss(xor_m9w, 18n, 3)
  alter @m.xdut.xfa8_0.xxor1.m9[l] = agauss(xor_m9l, 18n, 3)
  alter @m.xdut.xfa8_0.xxor2.m0[w] = agauss(xor_m0w, 18n, 3)
  alter @m.xdut.xfa8_0.xxor2.m0[l] = agauss(xor_m0l, 18n, 3)
  alter @m.xdut.xfa8_0.xxor2.m1[w] = agauss(xor_m1w, 18n, 3)
  alter @m.xdut.xfa8_0.xxor2.m1[l] = agauss(xor_m1l, 18n, 3)
  alter @m.xdut.xfa8_0.xxor2.m2[w] = agauss(xor_m2w, 18n, 3)
  alter @m.xdut.xfa8_0.xxor2.m2[l] = agauss(xor_m2l, 18n, 3)
  alter @m.xdut.xfa8_0.xxor2.m3[w] = agauss(xor_m3w, 18n, 3)
  alter @m.xdut.xfa8_0.xxor2.m3[l] = agauss(xor_m3l, 18n, 3)
  alter @m.xdut.xfa8_0.xxor2.m4[w] = agauss(xor_m4w, 18n, 3)
  alter @m.xdut.xfa8_0.xxor2.m4[l] = agauss(xor_m4l, 18n, 3)
  alter @m.xdut.xfa8_0.xxor2.m5[w] = agauss(xor_m5w, 18n, 3)
  alter @m.xdut.xfa8_0.xxor2.m5[l] = agauss(xor_m5l, 18n, 3)
  alter @m.xdut.xfa8_0.xxor2.m6[w] = agauss(xor_m6w, 18n, 3)
  alter @m.xdut.xfa8_0.xxor2.m6[l] = agauss(xor_m6l, 18n, 3)
  alter @m.xdut.xfa8_0.xxor2.m7[w] = agauss(xor_m7w, 18n, 3)
  alter @m.xdut.xfa8_0.xxor2.m7[l] = agauss(xor_m7l, 18n, 3)
  alter @m.xdut.xfa8_0.xxor2.m8[w] = agauss(xor_m8w, 18n, 3)
  alter @m.xdut.xfa8_0.xxor2.m8[l] = agauss(xor_m8l, 18n, 3)
  alter @m.xdut.xfa8_0.xxor2.m9[w] = agauss(xor_m9w, 18n, 3)
  alter @m.xdut.xfa8_0.xxor2.m9[l] = agauss(xor_m9l, 18n, 3)
  alter @m.xdut.xfa8_0.xmux1.mo0[w] = agauss(mux_mo0w, 18n, 3)
  alter @m.xdut.xfa8_0.xmux1.mo0[l] = agauss(mux_mo0l, 18n, 3)
  alter @m.xdut.xfa8_0.xmux1.mo1[w] = agauss(mux_mo1w, 18n, 3)
  alter @m.xdut.xfa8_0.xmux1.mo1[l] = agauss(mux_mo1l, 18n, 3)
  alter @m.xdut.xfa8_0.xmux1.m0[w] = agauss(mux_m0w, 18n, 3)
  alter @m.xdut.xfa8_0.xmux1.m0[l] = agauss(mux_m0l, 18n, 3)
  alter @m.xdut.xfa8_0.xmux1.m1[w] = agauss(mux_m1w, 18n, 3)
  alter @m.xdut.xfa8_0.xmux1.m1[l] = agauss(mux_m1l, 18n, 3)
  alter @m.xdut.xfa8_0.xmux1.m2[w] = agauss(mux_m2w, 18n, 3)
  alter @m.xdut.xfa8_0.xmux1.m2[l] = agauss(mux_m2l, 18n, 3)
  alter @m.xdut.xfa8_0.xmux1.m3[w] = agauss(mux_m3w, 18n, 3)
  alter @m.xdut.xfa8_0.xmux1.m3[l] = agauss(mux_m3l, 18n, 3)
  alter @m.xdut.xfa8_0.xmux1.m4[w] = agauss(mux_m4w, 18n, 3)
  alter @m.xdut.xfa8_0.xmux1.m4[l] = agauss(mux_m4l, 18n, 3)
  alter @m.xdut.xfa8_0.xmux1.m5[w] = agauss(mux_m5w, 18n, 3)
  alter @m.xdut.xfa8_0.xmux1.m5[l] = agauss(mux_m5l, 18n, 3)
  alter @m.xdut.xfa8_0.xmux1.m6[w] = agauss(mux_m6w, 18n, 3)
  alter @m.xdut.xfa8_0.xmux1.m6[l] = agauss(mux_m6l, 18n, 3)
  alter @m.xdut.xfa8_0.xmux1.m7[w] = agauss(mux_m7w, 18n, 3)
  alter @m.xdut.xfa8_0.xmux1.m7[l] = agauss(mux_m7l, 18n, 3)
  alter @m.xdut.xfa8_0.xmux1.m8[w] = agauss(mux_m8w, 18n, 3)
  alter @m.xdut.xfa8_0.xmux1.m8[l] = agauss(mux_m8l, 18n, 3)
  alter @m.xdut.xfa8_0.xmux1.m9[w] = agauss(mux_m9w, 18n, 3)
  alter @m.xdut.xfa8_0.xmux1.m9[l] = agauss(mux_m9l, 18n, 3)
  alter @m.xdut.xfa8_1.xxor1.m0[w] = agauss(xor_m0w, 18n, 3)
  alter @m.xdut.xfa8_1.xxor1.m0[l] = agauss(xor_m0l, 18n, 3)
  alter @m.xdut.xfa8_1.xxor1.m1[w] = agauss(xor_m1w, 18n, 3)
  alter @m.xdut.xfa8_1.xxor1.m1[l] = agauss(xor_m1l, 18n, 3)
  alter @m.xdut.xfa8_1.xxor1.m2[w] = agauss(xor_m2w, 18n, 3)
  alter @m.xdut.xfa8_1.xxor1.m2[l] = agauss(xor_m2l, 18n, 3)
  alter @m.xdut.xfa8_1.xxor1.m3[w] = agauss(xor_m3w, 18n, 3)
  alter @m.xdut.xfa8_1.xxor1.m3[l] = agauss(xor_m3l, 18n, 3)
  alter @m.xdut.xfa8_1.xxor1.m4[w] = agauss(xor_m4w, 18n, 3)
  alter @m.xdut.xfa8_1.xxor1.m4[l] = agauss(xor_m4l, 18n, 3)
  alter @m.xdut.xfa8_1.xxor1.m5[w] = agauss(xor_m5w, 18n, 3)
  alter @m.xdut.xfa8_1.xxor1.m5[l] = agauss(xor_m5l, 18n, 3)
  alter @m.xdut.xfa8_1.xxor1.m6[w] = agauss(xor_m6w, 18n, 3)
  alter @m.xdut.xfa8_1.xxor1.m6[l] = agauss(xor_m6l, 18n, 3)
  alter @m.xdut.xfa8_1.xxor1.m7[w] = agauss(xor_m7w, 18n, 3)
  alter @m.xdut.xfa8_1.xxor1.m7[l] = agauss(xor_m7l, 18n, 3)
  alter @m.xdut.xfa8_1.xxor1.m8[w] = agauss(xor_m8w, 18n, 3)
  alter @m.xdut.xfa8_1.xxor1.m8[l] = agauss(xor_m8l, 18n, 3)
  alter @m.xdut.xfa8_1.xxor1.m9[w] = agauss(xor_m9w, 18n, 3)
  alter @m.xdut.xfa8_1.xxor1.m9[l] = agauss(xor_m9l, 18n, 3)
  alter @m.xdut.xfa8_1.xxor2.m0[w] = agauss(xor_m0w, 18n, 3)
  alter @m.xdut.xfa8_1.xxor2.m0[l] = agauss(xor_m0l, 18n, 3)
  alter @m.xdut.xfa8_1.xxor2.m1[w] = agauss(xor_m1w, 18n, 3)
  alter @m.xdut.xfa8_1.xxor2.m1[l] = agauss(xor_m1l, 18n, 3)
  alter @m.xdut.xfa8_1.xxor2.m2[w] = agauss(xor_m2w, 18n, 3)
  alter @m.xdut.xfa8_1.xxor2.m2[l] = agauss(xor_m2l, 18n, 3)
  alter @m.xdut.xfa8_1.xxor2.m3[w] = agauss(xor_m3w, 18n, 3)
  alter @m.xdut.xfa8_1.xxor2.m3[l] = agauss(xor_m3l, 18n, 3)
  alter @m.xdut.xfa8_1.xxor2.m4[w] = agauss(xor_m4w, 18n, 3)
  alter @m.xdut.xfa8_1.xxor2.m4[l] = agauss(xor_m4l, 18n, 3)
  alter @m.xdut.xfa8_1.xxor2.m5[w] = agauss(xor_m5w, 18n, 3)
  alter @m.xdut.xfa8_1.xxor2.m5[l] = agauss(xor_m5l, 18n, 3)
  alter @m.xdut.xfa8_1.xxor2.m6[w] = agauss(xor_m6w, 18n, 3)
  alter @m.xdut.xfa8_1.xxor2.m6[l] = agauss(xor_m6l, 18n, 3)
  alter @m.xdut.xfa8_1.xxor2.m7[w] = agauss(xor_m7w, 18n, 3)
  alter @m.xdut.xfa8_1.xxor2.m7[l] = agauss(xor_m7l, 18n, 3)
  alter @m.xdut.xfa8_1.xxor2.m8[w] = agauss(xor_m8w, 18n, 3)
  alter @m.xdut.xfa8_1.xxor2.m8[l] = agauss(xor_m8l, 18n, 3)
  alter @m.xdut.xfa8_1.xxor2.m9[w] = agauss(xor_m9w, 18n, 3)
  alter @m.xdut.xfa8_1.xxor2.m9[l] = agauss(xor_m9l, 18n, 3)
  alter @m.xdut.xfa8_1.xmux1.mo0[w] = agauss(mux_mo0w, 18n, 3)
  alter @m.xdut.xfa8_1.xmux1.mo0[l] = agauss(mux_mo0l, 18n, 3)
  alter @m.xdut.xfa8_1.xmux1.mo1[w] = agauss(mux_mo1w, 18n, 3)
  alter @m.xdut.xfa8_1.xmux1.mo1[l] = agauss(mux_mo1l, 18n, 3)
  alter @m.xdut.xfa8_1.xmux1.m0[w] = agauss(mux_m0w, 18n, 3)
  alter @m.xdut.xfa8_1.xmux1.m0[l] = agauss(mux_m0l, 18n, 3)
  alter @m.xdut.xfa8_1.xmux1.m1[w] = agauss(mux_m1w, 18n, 3)
  alter @m.xdut.xfa8_1.xmux1.m1[l] = agauss(mux_m1l, 18n, 3)
  alter @m.xdut.xfa8_1.xmux1.m2[w] = agauss(mux_m2w, 18n, 3)
  alter @m.xdut.xfa8_1.xmux1.m2[l] = agauss(mux_m2l, 18n, 3)
  alter @m.xdut.xfa8_1.xmux1.m3[w] = agauss(mux_m3w, 18n, 3)
  alter @m.xdut.xfa8_1.xmux1.m3[l] = agauss(mux_m3l, 18n, 3)
  alter @m.xdut.xfa8_1.xmux1.m4[w] = agauss(mux_m4w, 18n, 3)
  alter @m.xdut.xfa8_1.xmux1.m4[l] = agauss(mux_m4l, 18n, 3)
  alter @m.xdut.xfa8_1.xmux1.m5[w] = agauss(mux_m5w, 18n, 3)
  alter @m.xdut.xfa8_1.xmux1.m5[l] = agauss(mux_m5l, 18n, 3)
  alter @m.xdut.xfa8_1.xmux1.m6[w] = agauss(mux_m6w, 18n, 3)
  alter @m.xdut.xfa8_1.xmux1.m6[l] = agauss(mux_m6l, 18n, 3)
  alter @m.xdut.xfa8_1.xmux1.m7[w] = agauss(mux_m7w, 18n, 3)
  alter @m.xdut.xfa8_1.xmux1.m7[l] = agauss(mux_m7l, 18n, 3)
  alter @m.xdut.xfa8_1.xmux1.m8[w] = agauss(mux_m8w, 18n, 3)
  alter @m.xdut.xfa8_1.xmux1.m8[l] = agauss(mux_m8l, 18n, 3)
  alter @m.xdut.xfa8_1.xmux1.m9[w] = agauss(mux_m9w, 18n, 3)
  alter @m.xdut.xfa8_1.xmux1.m9[l] = agauss(mux_m9l, 18n, 3)
  alter @m.xdut.xfa9_0.xxor1.m0[w] = agauss(xor_m0w, 18n, 3)
  alter @m.xdut.xfa9_0.xxor1.m0[l] = agauss(xor_m0l, 18n, 3)
  alter @m.xdut.xfa9_0.xxor1.m1[w] = agauss(xor_m1w, 18n, 3)
  alter @m.xdut.xfa9_0.xxor1.m1[l] = agauss(xor_m1l, 18n, 3)
  alter @m.xdut.xfa9_0.xxor1.m2[w] = agauss(xor_m2w, 18n, 3)
  alter @m.xdut.xfa9_0.xxor1.m2[l] = agauss(xor_m2l, 18n, 3)
  alter @m.xdut.xfa9_0.xxor1.m3[w] = agauss(xor_m3w, 18n, 3)
  alter @m.xdut.xfa9_0.xxor1.m3[l] = agauss(xor_m3l, 18n, 3)
  alter @m.xdut.xfa9_0.xxor1.m4[w] = agauss(xor_m4w, 18n, 3)
  alter @m.xdut.xfa9_0.xxor1.m4[l] = agauss(xor_m4l, 18n, 3)
  alter @m.xdut.xfa9_0.xxor1.m5[w] = agauss(xor_m5w, 18n, 3)
  alter @m.xdut.xfa9_0.xxor1.m5[l] = agauss(xor_m5l, 18n, 3)
  alter @m.xdut.xfa9_0.xxor1.m6[w] = agauss(xor_m6w, 18n, 3)
  alter @m.xdut.xfa9_0.xxor1.m6[l] = agauss(xor_m6l, 18n, 3)
  alter @m.xdut.xfa9_0.xxor1.m7[w] = agauss(xor_m7w, 18n, 3)
  alter @m.xdut.xfa9_0.xxor1.m7[l] = agauss(xor_m7l, 18n, 3)
  alter @m.xdut.xfa9_0.xxor1.m8[w] = agauss(xor_m8w, 18n, 3)
  alter @m.xdut.xfa9_0.xxor1.m8[l] = agauss(xor_m8l, 18n, 3)
  alter @m.xdut.xfa9_0.xxor1.m9[w] = agauss(xor_m9w, 18n, 3)
  alter @m.xdut.xfa9_0.xxor1.m9[l] = agauss(xor_m9l, 18n, 3)
  alter @m.xdut.xfa9_0.xxor2.m0[w] = agauss(xor_m0w, 18n, 3)
  alter @m.xdut.xfa9_0.xxor2.m0[l] = agauss(xor_m0l, 18n, 3)
  alter @m.xdut.xfa9_0.xxor2.m1[w] = agauss(xor_m1w, 18n, 3)
  alter @m.xdut.xfa9_0.xxor2.m1[l] = agauss(xor_m1l, 18n, 3)
  alter @m.xdut.xfa9_0.xxor2.m2[w] = agauss(xor_m2w, 18n, 3)
  alter @m.xdut.xfa9_0.xxor2.m2[l] = agauss(xor_m2l, 18n, 3)
  alter @m.xdut.xfa9_0.xxor2.m3[w] = agauss(xor_m3w, 18n, 3)
  alter @m.xdut.xfa9_0.xxor2.m3[l] = agauss(xor_m3l, 18n, 3)
  alter @m.xdut.xfa9_0.xxor2.m4[w] = agauss(xor_m4w, 18n, 3)
  alter @m.xdut.xfa9_0.xxor2.m4[l] = agauss(xor_m4l, 18n, 3)
  alter @m.xdut.xfa9_0.xxor2.m5[w] = agauss(xor_m5w, 18n, 3)
  alter @m.xdut.xfa9_0.xxor2.m5[l] = agauss(xor_m5l, 18n, 3)
  alter @m.xdut.xfa9_0.xxor2.m6[w] = agauss(xor_m6w, 18n, 3)
  alter @m.xdut.xfa9_0.xxor2.m6[l] = agauss(xor_m6l, 18n, 3)
  alter @m.xdut.xfa9_0.xxor2.m7[w] = agauss(xor_m7w, 18n, 3)
  alter @m.xdut.xfa9_0.xxor2.m7[l] = agauss(xor_m7l, 18n, 3)
  alter @m.xdut.xfa9_0.xxor2.m8[w] = agauss(xor_m8w, 18n, 3)
  alter @m.xdut.xfa9_0.xxor2.m8[l] = agauss(xor_m8l, 18n, 3)
  alter @m.xdut.xfa9_0.xxor2.m9[w] = agauss(xor_m9w, 18n, 3)
  alter @m.xdut.xfa9_0.xxor2.m9[l] = agauss(xor_m9l, 18n, 3)
  alter @m.xdut.xfa9_0.xmux1.mo0[w] = agauss(mux_mo0w, 18n, 3)
  alter @m.xdut.xfa9_0.xmux1.mo0[l] = agauss(mux_mo0l, 18n, 3)
  alter @m.xdut.xfa9_0.xmux1.mo1[w] = agauss(mux_mo1w, 18n, 3)
  alter @m.xdut.xfa9_0.xmux1.mo1[l] = agauss(mux_mo1l, 18n, 3)
  alter @m.xdut.xfa9_0.xmux1.m0[w] = agauss(mux_m0w, 18n, 3)
  alter @m.xdut.xfa9_0.xmux1.m0[l] = agauss(mux_m0l, 18n, 3)
  alter @m.xdut.xfa9_0.xmux1.m1[w] = agauss(mux_m1w, 18n, 3)
  alter @m.xdut.xfa9_0.xmux1.m1[l] = agauss(mux_m1l, 18n, 3)
  alter @m.xdut.xfa9_0.xmux1.m2[w] = agauss(mux_m2w, 18n, 3)
  alter @m.xdut.xfa9_0.xmux1.m2[l] = agauss(mux_m2l, 18n, 3)
  alter @m.xdut.xfa9_0.xmux1.m3[w] = agauss(mux_m3w, 18n, 3)
  alter @m.xdut.xfa9_0.xmux1.m3[l] = agauss(mux_m3l, 18n, 3)
  alter @m.xdut.xfa9_0.xmux1.m4[w] = agauss(mux_m4w, 18n, 3)
  alter @m.xdut.xfa9_0.xmux1.m4[l] = agauss(mux_m4l, 18n, 3)
  alter @m.xdut.xfa9_0.xmux1.m5[w] = agauss(mux_m5w, 18n, 3)
  alter @m.xdut.xfa9_0.xmux1.m5[l] = agauss(mux_m5l, 18n, 3)
  alter @m.xdut.xfa9_0.xmux1.m6[w] = agauss(mux_m6w, 18n, 3)
  alter @m.xdut.xfa9_0.xmux1.m6[l] = agauss(mux_m6l, 18n, 3)
  alter @m.xdut.xfa9_0.xmux1.m7[w] = agauss(mux_m7w, 18n, 3)
  alter @m.xdut.xfa9_0.xmux1.m7[l] = agauss(mux_m7l, 18n, 3)
  alter @m.xdut.xfa9_0.xmux1.m8[w] = agauss(mux_m8w, 18n, 3)
  alter @m.xdut.xfa9_0.xmux1.m8[l] = agauss(mux_m8l, 18n, 3)
  alter @m.xdut.xfa9_0.xmux1.m9[w] = agauss(mux_m9w, 18n, 3)
  alter @m.xdut.xfa9_0.xmux1.m9[l] = agauss(mux_m9l, 18n, 3)
  alter @m.xdut.xfa9_1.xxor1.m0[w] = agauss(xor_m0w, 18n, 3)
  alter @m.xdut.xfa9_1.xxor1.m0[l] = agauss(xor_m0l, 18n, 3)
  alter @m.xdut.xfa9_1.xxor1.m1[w] = agauss(xor_m1w, 18n, 3)
  alter @m.xdut.xfa9_1.xxor1.m1[l] = agauss(xor_m1l, 18n, 3)
  alter @m.xdut.xfa9_1.xxor1.m2[w] = agauss(xor_m2w, 18n, 3)
  alter @m.xdut.xfa9_1.xxor1.m2[l] = agauss(xor_m2l, 18n, 3)
  alter @m.xdut.xfa9_1.xxor1.m3[w] = agauss(xor_m3w, 18n, 3)
  alter @m.xdut.xfa9_1.xxor1.m3[l] = agauss(xor_m3l, 18n, 3)
  alter @m.xdut.xfa9_1.xxor1.m4[w] = agauss(xor_m4w, 18n, 3)
  alter @m.xdut.xfa9_1.xxor1.m4[l] = agauss(xor_m4l, 18n, 3)
  alter @m.xdut.xfa9_1.xxor1.m5[w] = agauss(xor_m5w, 18n, 3)
  alter @m.xdut.xfa9_1.xxor1.m5[l] = agauss(xor_m5l, 18n, 3)
  alter @m.xdut.xfa9_1.xxor1.m6[w] = agauss(xor_m6w, 18n, 3)
  alter @m.xdut.xfa9_1.xxor1.m6[l] = agauss(xor_m6l, 18n, 3)
  alter @m.xdut.xfa9_1.xxor1.m7[w] = agauss(xor_m7w, 18n, 3)
  alter @m.xdut.xfa9_1.xxor1.m7[l] = agauss(xor_m7l, 18n, 3)
  alter @m.xdut.xfa9_1.xxor1.m8[w] = agauss(xor_m8w, 18n, 3)
  alter @m.xdut.xfa9_1.xxor1.m8[l] = agauss(xor_m8l, 18n, 3)
  alter @m.xdut.xfa9_1.xxor1.m9[w] = agauss(xor_m9w, 18n, 3)
  alter @m.xdut.xfa9_1.xxor1.m9[l] = agauss(xor_m9l, 18n, 3)
  alter @m.xdut.xfa9_1.xxor2.m0[w] = agauss(xor_m0w, 18n, 3)
  alter @m.xdut.xfa9_1.xxor2.m0[l] = agauss(xor_m0l, 18n, 3)
  alter @m.xdut.xfa9_1.xxor2.m1[w] = agauss(xor_m1w, 18n, 3)
  alter @m.xdut.xfa9_1.xxor2.m1[l] = agauss(xor_m1l, 18n, 3)
  alter @m.xdut.xfa9_1.xxor2.m2[w] = agauss(xor_m2w, 18n, 3)
  alter @m.xdut.xfa9_1.xxor2.m2[l] = agauss(xor_m2l, 18n, 3)
  alter @m.xdut.xfa9_1.xxor2.m3[w] = agauss(xor_m3w, 18n, 3)
  alter @m.xdut.xfa9_1.xxor2.m3[l] = agauss(xor_m3l, 18n, 3)
  alter @m.xdut.xfa9_1.xxor2.m4[w] = agauss(xor_m4w, 18n, 3)
  alter @m.xdut.xfa9_1.xxor2.m4[l] = agauss(xor_m4l, 18n, 3)
  alter @m.xdut.xfa9_1.xxor2.m5[w] = agauss(xor_m5w, 18n, 3)
  alter @m.xdut.xfa9_1.xxor2.m5[l] = agauss(xor_m5l, 18n, 3)
  alter @m.xdut.xfa9_1.xxor2.m6[w] = agauss(xor_m6w, 18n, 3)
  alter @m.xdut.xfa9_1.xxor2.m6[l] = agauss(xor_m6l, 18n, 3)
  alter @m.xdut.xfa9_1.xxor2.m7[w] = agauss(xor_m7w, 18n, 3)
  alter @m.xdut.xfa9_1.xxor2.m7[l] = agauss(xor_m7l, 18n, 3)
  alter @m.xdut.xfa9_1.xxor2.m8[w] = agauss(xor_m8w, 18n, 3)
  alter @m.xdut.xfa9_1.xxor2.m8[l] = agauss(xor_m8l, 18n, 3)
  alter @m.xdut.xfa9_1.xxor2.m9[w] = agauss(xor_m9w, 18n, 3)
  alter @m.xdut.xfa9_1.xxor2.m9[l] = agauss(xor_m9l, 18n, 3)
  alter @m.xdut.xfa9_1.xmux1.mo0[w] = agauss(mux_mo0w, 18n, 3)
  alter @m.xdut.xfa9_1.xmux1.mo0[l] = agauss(mux_mo0l, 18n, 3)
  alter @m.xdut.xfa9_1.xmux1.mo1[w] = agauss(mux_mo1w, 18n, 3)
  alter @m.xdut.xfa9_1.xmux1.mo1[l] = agauss(mux_mo1l, 18n, 3)
  alter @m.xdut.xfa9_1.xmux1.m0[w] = agauss(mux_m0w, 18n, 3)
  alter @m.xdut.xfa9_1.xmux1.m0[l] = agauss(mux_m0l, 18n, 3)
  alter @m.xdut.xfa9_1.xmux1.m1[w] = agauss(mux_m1w, 18n, 3)
  alter @m.xdut.xfa9_1.xmux1.m1[l] = agauss(mux_m1l, 18n, 3)
  alter @m.xdut.xfa9_1.xmux1.m2[w] = agauss(mux_m2w, 18n, 3)
  alter @m.xdut.xfa9_1.xmux1.m2[l] = agauss(mux_m2l, 18n, 3)
  alter @m.xdut.xfa9_1.xmux1.m3[w] = agauss(mux_m3w, 18n, 3)
  alter @m.xdut.xfa9_1.xmux1.m3[l] = agauss(mux_m3l, 18n, 3)
  alter @m.xdut.xfa9_1.xmux1.m4[w] = agauss(mux_m4w, 18n, 3)
  alter @m.xdut.xfa9_1.xmux1.m4[l] = agauss(mux_m4l, 18n, 3)
  alter @m.xdut.xfa9_1.xmux1.m5[w] = agauss(mux_m5w, 18n, 3)
  alter @m.xdut.xfa9_1.xmux1.m5[l] = agauss(mux_m5l, 18n, 3)
  alter @m.xdut.xfa9_1.xmux1.m6[w] = agauss(mux_m6w, 18n, 3)
  alter @m.xdut.xfa9_1.xmux1.m6[l] = agauss(mux_m6l, 18n, 3)
  alter @m.xdut.xfa9_1.xmux1.m7[w] = agauss(mux_m7w, 18n, 3)
  alter @m.xdut.xfa9_1.xmux1.m7[l] = agauss(mux_m7l, 18n, 3)
  alter @m.xdut.xfa9_1.xmux1.m8[w] = agauss(mux_m8w, 18n, 3)
  alter @m.xdut.xfa9_1.xmux1.m8[l] = agauss(mux_m8l, 18n, 3)
  alter @m.xdut.xfa9_1.xmux1.m9[w] = agauss(mux_m9w, 18n, 3)
  alter @m.xdut.xfa9_1.xmux1.m9[l] = agauss(mux_m9l, 18n, 3)
  alter @m.xdut.xfaa_0.xxor1.m0[w] = agauss(xor_m0w, 18n, 3)
  alter @m.xdut.xfaa_0.xxor1.m0[l] = agauss(xor_m0l, 18n, 3)
  alter @m.xdut.xfaa_0.xxor1.m1[w] = agauss(xor_m1w, 18n, 3)
  alter @m.xdut.xfaa_0.xxor1.m1[l] = agauss(xor_m1l, 18n, 3)
  alter @m.xdut.xfaa_0.xxor1.m2[w] = agauss(xor_m2w, 18n, 3)
  alter @m.xdut.xfaa_0.xxor1.m2[l] = agauss(xor_m2l, 18n, 3)
  alter @m.xdut.xfaa_0.xxor1.m3[w] = agauss(xor_m3w, 18n, 3)
  alter @m.xdut.xfaa_0.xxor1.m3[l] = agauss(xor_m3l, 18n, 3)
  alter @m.xdut.xfaa_0.xxor1.m4[w] = agauss(xor_m4w, 18n, 3)
  alter @m.xdut.xfaa_0.xxor1.m4[l] = agauss(xor_m4l, 18n, 3)
  alter @m.xdut.xfaa_0.xxor1.m5[w] = agauss(xor_m5w, 18n, 3)
  alter @m.xdut.xfaa_0.xxor1.m5[l] = agauss(xor_m5l, 18n, 3)
  alter @m.xdut.xfaa_0.xxor1.m6[w] = agauss(xor_m6w, 18n, 3)
  alter @m.xdut.xfaa_0.xxor1.m6[l] = agauss(xor_m6l, 18n, 3)
  alter @m.xdut.xfaa_0.xxor1.m7[w] = agauss(xor_m7w, 18n, 3)
  alter @m.xdut.xfaa_0.xxor1.m7[l] = agauss(xor_m7l, 18n, 3)
  alter @m.xdut.xfaa_0.xxor1.m8[w] = agauss(xor_m8w, 18n, 3)
  alter @m.xdut.xfaa_0.xxor1.m8[l] = agauss(xor_m8l, 18n, 3)
  alter @m.xdut.xfaa_0.xxor1.m9[w] = agauss(xor_m9w, 18n, 3)
  alter @m.xdut.xfaa_0.xxor1.m9[l] = agauss(xor_m9l, 18n, 3)
  alter @m.xdut.xfaa_0.xxor2.m0[w] = agauss(xor_m0w, 18n, 3)
  alter @m.xdut.xfaa_0.xxor2.m0[l] = agauss(xor_m0l, 18n, 3)
  alter @m.xdut.xfaa_0.xxor2.m1[w] = agauss(xor_m1w, 18n, 3)
  alter @m.xdut.xfaa_0.xxor2.m1[l] = agauss(xor_m1l, 18n, 3)
  alter @m.xdut.xfaa_0.xxor2.m2[w] = agauss(xor_m2w, 18n, 3)
  alter @m.xdut.xfaa_0.xxor2.m2[l] = agauss(xor_m2l, 18n, 3)
  alter @m.xdut.xfaa_0.xxor2.m3[w] = agauss(xor_m3w, 18n, 3)
  alter @m.xdut.xfaa_0.xxor2.m3[l] = agauss(xor_m3l, 18n, 3)
  alter @m.xdut.xfaa_0.xxor2.m4[w] = agauss(xor_m4w, 18n, 3)
  alter @m.xdut.xfaa_0.xxor2.m4[l] = agauss(xor_m4l, 18n, 3)
  alter @m.xdut.xfaa_0.xxor2.m5[w] = agauss(xor_m5w, 18n, 3)
  alter @m.xdut.xfaa_0.xxor2.m5[l] = agauss(xor_m5l, 18n, 3)
  alter @m.xdut.xfaa_0.xxor2.m6[w] = agauss(xor_m6w, 18n, 3)
  alter @m.xdut.xfaa_0.xxor2.m6[l] = agauss(xor_m6l, 18n, 3)
  alter @m.xdut.xfaa_0.xxor2.m7[w] = agauss(xor_m7w, 18n, 3)
  alter @m.xdut.xfaa_0.xxor2.m7[l] = agauss(xor_m7l, 18n, 3)
  alter @m.xdut.xfaa_0.xxor2.m8[w] = agauss(xor_m8w, 18n, 3)
  alter @m.xdut.xfaa_0.xxor2.m8[l] = agauss(xor_m8l, 18n, 3)
  alter @m.xdut.xfaa_0.xxor2.m9[w] = agauss(xor_m9w, 18n, 3)
  alter @m.xdut.xfaa_0.xxor2.m9[l] = agauss(xor_m9l, 18n, 3)
  alter @m.xdut.xfaa_0.xmux1.mo0[w] = agauss(mux_mo0w, 18n, 3)
  alter @m.xdut.xfaa_0.xmux1.mo0[l] = agauss(mux_mo0l, 18n, 3)
  alter @m.xdut.xfaa_0.xmux1.mo1[w] = agauss(mux_mo1w, 18n, 3)
  alter @m.xdut.xfaa_0.xmux1.mo1[l] = agauss(mux_mo1l, 18n, 3)
  alter @m.xdut.xfaa_0.xmux1.m0[w] = agauss(mux_m0w, 18n, 3)
  alter @m.xdut.xfaa_0.xmux1.m0[l] = agauss(mux_m0l, 18n, 3)
  alter @m.xdut.xfaa_0.xmux1.m1[w] = agauss(mux_m1w, 18n, 3)
  alter @m.xdut.xfaa_0.xmux1.m1[l] = agauss(mux_m1l, 18n, 3)
  alter @m.xdut.xfaa_0.xmux1.m2[w] = agauss(mux_m2w, 18n, 3)
  alter @m.xdut.xfaa_0.xmux1.m2[l] = agauss(mux_m2l, 18n, 3)
  alter @m.xdut.xfaa_0.xmux1.m3[w] = agauss(mux_m3w, 18n, 3)
  alter @m.xdut.xfaa_0.xmux1.m3[l] = agauss(mux_m3l, 18n, 3)
  alter @m.xdut.xfaa_0.xmux1.m4[w] = agauss(mux_m4w, 18n, 3)
  alter @m.xdut.xfaa_0.xmux1.m4[l] = agauss(mux_m4l, 18n, 3)
  alter @m.xdut.xfaa_0.xmux1.m5[w] = agauss(mux_m5w, 18n, 3)
  alter @m.xdut.xfaa_0.xmux1.m5[l] = agauss(mux_m5l, 18n, 3)
  alter @m.xdut.xfaa_0.xmux1.m6[w] = agauss(mux_m6w, 18n, 3)
  alter @m.xdut.xfaa_0.xmux1.m6[l] = agauss(mux_m6l, 18n, 3)
  alter @m.xdut.xfaa_0.xmux1.m7[w] = agauss(mux_m7w, 18n, 3)
  alter @m.xdut.xfaa_0.xmux1.m7[l] = agauss(mux_m7l, 18n, 3)
  alter @m.xdut.xfaa_0.xmux1.m8[w] = agauss(mux_m8w, 18n, 3)
  alter @m.xdut.xfaa_0.xmux1.m8[l] = agauss(mux_m8l, 18n, 3)
  alter @m.xdut.xfaa_0.xmux1.m9[w] = agauss(mux_m9w, 18n, 3)
  alter @m.xdut.xfaa_0.xmux1.m9[l] = agauss(mux_m9l, 18n, 3)
  alter @m.xdut.xfaa_1.xxor1.m0[w] = agauss(xor_m0w, 18n, 3)
  alter @m.xdut.xfaa_1.xxor1.m0[l] = agauss(xor_m0l, 18n, 3)
  alter @m.xdut.xfaa_1.xxor1.m1[w] = agauss(xor_m1w, 18n, 3)
  alter @m.xdut.xfaa_1.xxor1.m1[l] = agauss(xor_m1l, 18n, 3)
  alter @m.xdut.xfaa_1.xxor1.m2[w] = agauss(xor_m2w, 18n, 3)
  alter @m.xdut.xfaa_1.xxor1.m2[l] = agauss(xor_m2l, 18n, 3)
  alter @m.xdut.xfaa_1.xxor1.m3[w] = agauss(xor_m3w, 18n, 3)
  alter @m.xdut.xfaa_1.xxor1.m3[l] = agauss(xor_m3l, 18n, 3)
  alter @m.xdut.xfaa_1.xxor1.m4[w] = agauss(xor_m4w, 18n, 3)
  alter @m.xdut.xfaa_1.xxor1.m4[l] = agauss(xor_m4l, 18n, 3)
  alter @m.xdut.xfaa_1.xxor1.m5[w] = agauss(xor_m5w, 18n, 3)
  alter @m.xdut.xfaa_1.xxor1.m5[l] = agauss(xor_m5l, 18n, 3)
  alter @m.xdut.xfaa_1.xxor1.m6[w] = agauss(xor_m6w, 18n, 3)
  alter @m.xdut.xfaa_1.xxor1.m6[l] = agauss(xor_m6l, 18n, 3)
  alter @m.xdut.xfaa_1.xxor1.m7[w] = agauss(xor_m7w, 18n, 3)
  alter @m.xdut.xfaa_1.xxor1.m7[l] = agauss(xor_m7l, 18n, 3)
  alter @m.xdut.xfaa_1.xxor1.m8[w] = agauss(xor_m8w, 18n, 3)
  alter @m.xdut.xfaa_1.xxor1.m8[l] = agauss(xor_m8l, 18n, 3)
  alter @m.xdut.xfaa_1.xxor1.m9[w] = agauss(xor_m9w, 18n, 3)
  alter @m.xdut.xfaa_1.xxor1.m9[l] = agauss(xor_m9l, 18n, 3)
  alter @m.xdut.xfaa_1.xxor2.m0[w] = agauss(xor_m0w, 18n, 3)
  alter @m.xdut.xfaa_1.xxor2.m0[l] = agauss(xor_m0l, 18n, 3)
  alter @m.xdut.xfaa_1.xxor2.m1[w] = agauss(xor_m1w, 18n, 3)
  alter @m.xdut.xfaa_1.xxor2.m1[l] = agauss(xor_m1l, 18n, 3)
  alter @m.xdut.xfaa_1.xxor2.m2[w] = agauss(xor_m2w, 18n, 3)
  alter @m.xdut.xfaa_1.xxor2.m2[l] = agauss(xor_m2l, 18n, 3)
  alter @m.xdut.xfaa_1.xxor2.m3[w] = agauss(xor_m3w, 18n, 3)
  alter @m.xdut.xfaa_1.xxor2.m3[l] = agauss(xor_m3l, 18n, 3)
  alter @m.xdut.xfaa_1.xxor2.m4[w] = agauss(xor_m4w, 18n, 3)
  alter @m.xdut.xfaa_1.xxor2.m4[l] = agauss(xor_m4l, 18n, 3)
  alter @m.xdut.xfaa_1.xxor2.m5[w] = agauss(xor_m5w, 18n, 3)
  alter @m.xdut.xfaa_1.xxor2.m5[l] = agauss(xor_m5l, 18n, 3)
  alter @m.xdut.xfaa_1.xxor2.m6[w] = agauss(xor_m6w, 18n, 3)
  alter @m.xdut.xfaa_1.xxor2.m6[l] = agauss(xor_m6l, 18n, 3)
  alter @m.xdut.xfaa_1.xxor2.m7[w] = agauss(xor_m7w, 18n, 3)
  alter @m.xdut.xfaa_1.xxor2.m7[l] = agauss(xor_m7l, 18n, 3)
  alter @m.xdut.xfaa_1.xxor2.m8[w] = agauss(xor_m8w, 18n, 3)
  alter @m.xdut.xfaa_1.xxor2.m8[l] = agauss(xor_m8l, 18n, 3)
  alter @m.xdut.xfaa_1.xxor2.m9[w] = agauss(xor_m9w, 18n, 3)
  alter @m.xdut.xfaa_1.xxor2.m9[l] = agauss(xor_m9l, 18n, 3)
  alter @m.xdut.xfaa_1.xmux1.mo0[w] = agauss(mux_mo0w, 18n, 3)
  alter @m.xdut.xfaa_1.xmux1.mo0[l] = agauss(mux_mo0l, 18n, 3)
  alter @m.xdut.xfaa_1.xmux1.mo1[w] = agauss(mux_mo1w, 18n, 3)
  alter @m.xdut.xfaa_1.xmux1.mo1[l] = agauss(mux_mo1l, 18n, 3)
  alter @m.xdut.xfaa_1.xmux1.m0[w] = agauss(mux_m0w, 18n, 3)
  alter @m.xdut.xfaa_1.xmux1.m0[l] = agauss(mux_m0l, 18n, 3)
  alter @m.xdut.xfaa_1.xmux1.m1[w] = agauss(mux_m1w, 18n, 3)
  alter @m.xdut.xfaa_1.xmux1.m1[l] = agauss(mux_m1l, 18n, 3)
  alter @m.xdut.xfaa_1.xmux1.m2[w] = agauss(mux_m2w, 18n, 3)
  alter @m.xdut.xfaa_1.xmux1.m2[l] = agauss(mux_m2l, 18n, 3)
  alter @m.xdut.xfaa_1.xmux1.m3[w] = agauss(mux_m3w, 18n, 3)
  alter @m.xdut.xfaa_1.xmux1.m3[l] = agauss(mux_m3l, 18n, 3)
  alter @m.xdut.xfaa_1.xmux1.m4[w] = agauss(mux_m4w, 18n, 3)
  alter @m.xdut.xfaa_1.xmux1.m4[l] = agauss(mux_m4l, 18n, 3)
  alter @m.xdut.xfaa_1.xmux1.m5[w] = agauss(mux_m5w, 18n, 3)
  alter @m.xdut.xfaa_1.xmux1.m5[l] = agauss(mux_m5l, 18n, 3)
  alter @m.xdut.xfaa_1.xmux1.m6[w] = agauss(mux_m6w, 18n, 3)
  alter @m.xdut.xfaa_1.xmux1.m6[l] = agauss(mux_m6l, 18n, 3)
  alter @m.xdut.xfaa_1.xmux1.m7[w] = agauss(mux_m7w, 18n, 3)
  alter @m.xdut.xfaa_1.xmux1.m7[l] = agauss(mux_m7l, 18n, 3)
  alter @m.xdut.xfaa_1.xmux1.m8[w] = agauss(mux_m8w, 18n, 3)
  alter @m.xdut.xfaa_1.xmux1.m8[l] = agauss(mux_m8l, 18n, 3)
  alter @m.xdut.xfaa_1.xmux1.m9[w] = agauss(mux_m9w, 18n, 3)
  alter @m.xdut.xfaa_1.xmux1.m9[l] = agauss(mux_m9l, 18n, 3)
  alter @m.xdut.xfab_0.xxor1.m0[w] = agauss(xor_m0w, 18n, 3)
  alter @m.xdut.xfab_0.xxor1.m0[l] = agauss(xor_m0l, 18n, 3)
  alter @m.xdut.xfab_0.xxor1.m1[w] = agauss(xor_m1w, 18n, 3)
  alter @m.xdut.xfab_0.xxor1.m1[l] = agauss(xor_m1l, 18n, 3)
  alter @m.xdut.xfab_0.xxor1.m2[w] = agauss(xor_m2w, 18n, 3)
  alter @m.xdut.xfab_0.xxor1.m2[l] = agauss(xor_m2l, 18n, 3)
  alter @m.xdut.xfab_0.xxor1.m3[w] = agauss(xor_m3w, 18n, 3)
  alter @m.xdut.xfab_0.xxor1.m3[l] = agauss(xor_m3l, 18n, 3)
  alter @m.xdut.xfab_0.xxor1.m4[w] = agauss(xor_m4w, 18n, 3)
  alter @m.xdut.xfab_0.xxor1.m4[l] = agauss(xor_m4l, 18n, 3)
  alter @m.xdut.xfab_0.xxor1.m5[w] = agauss(xor_m5w, 18n, 3)
  alter @m.xdut.xfab_0.xxor1.m5[l] = agauss(xor_m5l, 18n, 3)
  alter @m.xdut.xfab_0.xxor1.m6[w] = agauss(xor_m6w, 18n, 3)
  alter @m.xdut.xfab_0.xxor1.m6[l] = agauss(xor_m6l, 18n, 3)
  alter @m.xdut.xfab_0.xxor1.m7[w] = agauss(xor_m7w, 18n, 3)
  alter @m.xdut.xfab_0.xxor1.m7[l] = agauss(xor_m7l, 18n, 3)
  alter @m.xdut.xfab_0.xxor1.m8[w] = agauss(xor_m8w, 18n, 3)
  alter @m.xdut.xfab_0.xxor1.m8[l] = agauss(xor_m8l, 18n, 3)
  alter @m.xdut.xfab_0.xxor1.m9[w] = agauss(xor_m9w, 18n, 3)
  alter @m.xdut.xfab_0.xxor1.m9[l] = agauss(xor_m9l, 18n, 3)
  alter @m.xdut.xfab_0.xxor2.m0[w] = agauss(xor_m0w, 18n, 3)
  alter @m.xdut.xfab_0.xxor2.m0[l] = agauss(xor_m0l, 18n, 3)
  alter @m.xdut.xfab_0.xxor2.m1[w] = agauss(xor_m1w, 18n, 3)
  alter @m.xdut.xfab_0.xxor2.m1[l] = agauss(xor_m1l, 18n, 3)
  alter @m.xdut.xfab_0.xxor2.m2[w] = agauss(xor_m2w, 18n, 3)
  alter @m.xdut.xfab_0.xxor2.m2[l] = agauss(xor_m2l, 18n, 3)
  alter @m.xdut.xfab_0.xxor2.m3[w] = agauss(xor_m3w, 18n, 3)
  alter @m.xdut.xfab_0.xxor2.m3[l] = agauss(xor_m3l, 18n, 3)
  alter @m.xdut.xfab_0.xxor2.m4[w] = agauss(xor_m4w, 18n, 3)
  alter @m.xdut.xfab_0.xxor2.m4[l] = agauss(xor_m4l, 18n, 3)
  alter @m.xdut.xfab_0.xxor2.m5[w] = agauss(xor_m5w, 18n, 3)
  alter @m.xdut.xfab_0.xxor2.m5[l] = agauss(xor_m5l, 18n, 3)
  alter @m.xdut.xfab_0.xxor2.m6[w] = agauss(xor_m6w, 18n, 3)
  alter @m.xdut.xfab_0.xxor2.m6[l] = agauss(xor_m6l, 18n, 3)
  alter @m.xdut.xfab_0.xxor2.m7[w] = agauss(xor_m7w, 18n, 3)
  alter @m.xdut.xfab_0.xxor2.m7[l] = agauss(xor_m7l, 18n, 3)
  alter @m.xdut.xfab_0.xxor2.m8[w] = agauss(xor_m8w, 18n, 3)
  alter @m.xdut.xfab_0.xxor2.m8[l] = agauss(xor_m8l, 18n, 3)
  alter @m.xdut.xfab_0.xxor2.m9[w] = agauss(xor_m9w, 18n, 3)
  alter @m.xdut.xfab_0.xxor2.m9[l] = agauss(xor_m9l, 18n, 3)
  alter @m.xdut.xfab_0.xmux1.mo0[w] = agauss(mux_mo0w, 18n, 3)
  alter @m.xdut.xfab_0.xmux1.mo0[l] = agauss(mux_mo0l, 18n, 3)
  alter @m.xdut.xfab_0.xmux1.mo1[w] = agauss(mux_mo1w, 18n, 3)
  alter @m.xdut.xfab_0.xmux1.mo1[l] = agauss(mux_mo1l, 18n, 3)
  alter @m.xdut.xfab_0.xmux1.m0[w] = agauss(mux_m0w, 18n, 3)
  alter @m.xdut.xfab_0.xmux1.m0[l] = agauss(mux_m0l, 18n, 3)
  alter @m.xdut.xfab_0.xmux1.m1[w] = agauss(mux_m1w, 18n, 3)
  alter @m.xdut.xfab_0.xmux1.m1[l] = agauss(mux_m1l, 18n, 3)
  alter @m.xdut.xfab_0.xmux1.m2[w] = agauss(mux_m2w, 18n, 3)
  alter @m.xdut.xfab_0.xmux1.m2[l] = agauss(mux_m2l, 18n, 3)
  alter @m.xdut.xfab_0.xmux1.m3[w] = agauss(mux_m3w, 18n, 3)
  alter @m.xdut.xfab_0.xmux1.m3[l] = agauss(mux_m3l, 18n, 3)
  alter @m.xdut.xfab_0.xmux1.m4[w] = agauss(mux_m4w, 18n, 3)
  alter @m.xdut.xfab_0.xmux1.m4[l] = agauss(mux_m4l, 18n, 3)
  alter @m.xdut.xfab_0.xmux1.m5[w] = agauss(mux_m5w, 18n, 3)
  alter @m.xdut.xfab_0.xmux1.m5[l] = agauss(mux_m5l, 18n, 3)
  alter @m.xdut.xfab_0.xmux1.m6[w] = agauss(mux_m6w, 18n, 3)
  alter @m.xdut.xfab_0.xmux1.m6[l] = agauss(mux_m6l, 18n, 3)
  alter @m.xdut.xfab_0.xmux1.m7[w] = agauss(mux_m7w, 18n, 3)
  alter @m.xdut.xfab_0.xmux1.m7[l] = agauss(mux_m7l, 18n, 3)
  alter @m.xdut.xfab_0.xmux1.m8[w] = agauss(mux_m8w, 18n, 3)
  alter @m.xdut.xfab_0.xmux1.m8[l] = agauss(mux_m8l, 18n, 3)
  alter @m.xdut.xfab_0.xmux1.m9[w] = agauss(mux_m9w, 18n, 3)
  alter @m.xdut.xfab_0.xmux1.m9[l] = agauss(mux_m9l, 18n, 3)
  alter @m.xdut.xfab_1.xxor1.m0[w] = agauss(xor_m0w, 18n, 3)
  alter @m.xdut.xfab_1.xxor1.m0[l] = agauss(xor_m0l, 18n, 3)
  alter @m.xdut.xfab_1.xxor1.m1[w] = agauss(xor_m1w, 18n, 3)
  alter @m.xdut.xfab_1.xxor1.m1[l] = agauss(xor_m1l, 18n, 3)
  alter @m.xdut.xfab_1.xxor1.m2[w] = agauss(xor_m2w, 18n, 3)
  alter @m.xdut.xfab_1.xxor1.m2[l] = agauss(xor_m2l, 18n, 3)
  alter @m.xdut.xfab_1.xxor1.m3[w] = agauss(xor_m3w, 18n, 3)
  alter @m.xdut.xfab_1.xxor1.m3[l] = agauss(xor_m3l, 18n, 3)
  alter @m.xdut.xfab_1.xxor1.m4[w] = agauss(xor_m4w, 18n, 3)
  alter @m.xdut.xfab_1.xxor1.m4[l] = agauss(xor_m4l, 18n, 3)
  alter @m.xdut.xfab_1.xxor1.m5[w] = agauss(xor_m5w, 18n, 3)
  alter @m.xdut.xfab_1.xxor1.m5[l] = agauss(xor_m5l, 18n, 3)
  alter @m.xdut.xfab_1.xxor1.m6[w] = agauss(xor_m6w, 18n, 3)
  alter @m.xdut.xfab_1.xxor1.m6[l] = agauss(xor_m6l, 18n, 3)
  alter @m.xdut.xfab_1.xxor1.m7[w] = agauss(xor_m7w, 18n, 3)
  alter @m.xdut.xfab_1.xxor1.m7[l] = agauss(xor_m7l, 18n, 3)
  alter @m.xdut.xfab_1.xxor1.m8[w] = agauss(xor_m8w, 18n, 3)
  alter @m.xdut.xfab_1.xxor1.m8[l] = agauss(xor_m8l, 18n, 3)
  alter @m.xdut.xfab_1.xxor1.m9[w] = agauss(xor_m9w, 18n, 3)
  alter @m.xdut.xfab_1.xxor1.m9[l] = agauss(xor_m9l, 18n, 3)
  alter @m.xdut.xfab_1.xxor2.m0[w] = agauss(xor_m0w, 18n, 3)
  alter @m.xdut.xfab_1.xxor2.m0[l] = agauss(xor_m0l, 18n, 3)
  alter @m.xdut.xfab_1.xxor2.m1[w] = agauss(xor_m1w, 18n, 3)
  alter @m.xdut.xfab_1.xxor2.m1[l] = agauss(xor_m1l, 18n, 3)
  alter @m.xdut.xfab_1.xxor2.m2[w] = agauss(xor_m2w, 18n, 3)
  alter @m.xdut.xfab_1.xxor2.m2[l] = agauss(xor_m2l, 18n, 3)
  alter @m.xdut.xfab_1.xxor2.m3[w] = agauss(xor_m3w, 18n, 3)
  alter @m.xdut.xfab_1.xxor2.m3[l] = agauss(xor_m3l, 18n, 3)
  alter @m.xdut.xfab_1.xxor2.m4[w] = agauss(xor_m4w, 18n, 3)
  alter @m.xdut.xfab_1.xxor2.m4[l] = agauss(xor_m4l, 18n, 3)
  alter @m.xdut.xfab_1.xxor2.m5[w] = agauss(xor_m5w, 18n, 3)
  alter @m.xdut.xfab_1.xxor2.m5[l] = agauss(xor_m5l, 18n, 3)
  alter @m.xdut.xfab_1.xxor2.m6[w] = agauss(xor_m6w, 18n, 3)
  alter @m.xdut.xfab_1.xxor2.m6[l] = agauss(xor_m6l, 18n, 3)
  alter @m.xdut.xfab_1.xxor2.m7[w] = agauss(xor_m7w, 18n, 3)
  alter @m.xdut.xfab_1.xxor2.m7[l] = agauss(xor_m7l, 18n, 3)
  alter @m.xdut.xfab_1.xxor2.m8[w] = agauss(xor_m8w, 18n, 3)
  alter @m.xdut.xfab_1.xxor2.m8[l] = agauss(xor_m8l, 18n, 3)
  alter @m.xdut.xfab_1.xxor2.m9[w] = agauss(xor_m9w, 18n, 3)
  alter @m.xdut.xfab_1.xxor2.m9[l] = agauss(xor_m9l, 18n, 3)
  alter @m.xdut.xfab_1.xmux1.mo0[w] = agauss(mux_mo0w, 18n, 3)
  alter @m.xdut.xfab_1.xmux1.mo0[l] = agauss(mux_mo0l, 18n, 3)
  alter @m.xdut.xfab_1.xmux1.mo1[w] = agauss(mux_mo1w, 18n, 3)
  alter @m.xdut.xfab_1.xmux1.mo1[l] = agauss(mux_mo1l, 18n, 3)
  alter @m.xdut.xfab_1.xmux1.m0[w] = agauss(mux_m0w, 18n, 3)
  alter @m.xdut.xfab_1.xmux1.m0[l] = agauss(mux_m0l, 18n, 3)
  alter @m.xdut.xfab_1.xmux1.m1[w] = agauss(mux_m1w, 18n, 3)
  alter @m.xdut.xfab_1.xmux1.m1[l] = agauss(mux_m1l, 18n, 3)
  alter @m.xdut.xfab_1.xmux1.m2[w] = agauss(mux_m2w, 18n, 3)
  alter @m.xdut.xfab_1.xmux1.m2[l] = agauss(mux_m2l, 18n, 3)
  alter @m.xdut.xfab_1.xmux1.m3[w] = agauss(mux_m3w, 18n, 3)
  alter @m.xdut.xfab_1.xmux1.m3[l] = agauss(mux_m3l, 18n, 3)
  alter @m.xdut.xfab_1.xmux1.m4[w] = agauss(mux_m4w, 18n, 3)
  alter @m.xdut.xfab_1.xmux1.m4[l] = agauss(mux_m4l, 18n, 3)
  alter @m.xdut.xfab_1.xmux1.m5[w] = agauss(mux_m5w, 18n, 3)
  alter @m.xdut.xfab_1.xmux1.m5[l] = agauss(mux_m5l, 18n, 3)
  alter @m.xdut.xfab_1.xmux1.m6[w] = agauss(mux_m6w, 18n, 3)
  alter @m.xdut.xfab_1.xmux1.m6[l] = agauss(mux_m6l, 18n, 3)
  alter @m.xdut.xfab_1.xmux1.m7[w] = agauss(mux_m7w, 18n, 3)
  alter @m.xdut.xfab_1.xmux1.m7[l] = agauss(mux_m7l, 18n, 3)
  alter @m.xdut.xfab_1.xmux1.m8[w] = agauss(mux_m8w, 18n, 3)
  alter @m.xdut.xfab_1.xmux1.m8[l] = agauss(mux_m8l, 18n, 3)
  alter @m.xdut.xfab_1.xmux1.m9[w] = agauss(mux_m9w, 18n, 3)
  alter @m.xdut.xfab_1.xmux1.m9[l] = agauss(mux_m9l, 18n, 3)
  alter @m.xdut.xfac_0.xxor1.m0[w] = agauss(xor_m0w, 18n, 3)
  alter @m.xdut.xfac_0.xxor1.m0[l] = agauss(xor_m0l, 18n, 3)
  alter @m.xdut.xfac_0.xxor1.m1[w] = agauss(xor_m1w, 18n, 3)
  alter @m.xdut.xfac_0.xxor1.m1[l] = agauss(xor_m1l, 18n, 3)
  alter @m.xdut.xfac_0.xxor1.m2[w] = agauss(xor_m2w, 18n, 3)
  alter @m.xdut.xfac_0.xxor1.m2[l] = agauss(xor_m2l, 18n, 3)
  alter @m.xdut.xfac_0.xxor1.m3[w] = agauss(xor_m3w, 18n, 3)
  alter @m.xdut.xfac_0.xxor1.m3[l] = agauss(xor_m3l, 18n, 3)
  alter @m.xdut.xfac_0.xxor1.m4[w] = agauss(xor_m4w, 18n, 3)
  alter @m.xdut.xfac_0.xxor1.m4[l] = agauss(xor_m4l, 18n, 3)
  alter @m.xdut.xfac_0.xxor1.m5[w] = agauss(xor_m5w, 18n, 3)
  alter @m.xdut.xfac_0.xxor1.m5[l] = agauss(xor_m5l, 18n, 3)
  alter @m.xdut.xfac_0.xxor1.m6[w] = agauss(xor_m6w, 18n, 3)
  alter @m.xdut.xfac_0.xxor1.m6[l] = agauss(xor_m6l, 18n, 3)
  alter @m.xdut.xfac_0.xxor1.m7[w] = agauss(xor_m7w, 18n, 3)
  alter @m.xdut.xfac_0.xxor1.m7[l] = agauss(xor_m7l, 18n, 3)
  alter @m.xdut.xfac_0.xxor1.m8[w] = agauss(xor_m8w, 18n, 3)
  alter @m.xdut.xfac_0.xxor1.m8[l] = agauss(xor_m8l, 18n, 3)
  alter @m.xdut.xfac_0.xxor1.m9[w] = agauss(xor_m9w, 18n, 3)
  alter @m.xdut.xfac_0.xxor1.m9[l] = agauss(xor_m9l, 18n, 3)
  alter @m.xdut.xfac_0.xxor2.m0[w] = agauss(xor_m0w, 18n, 3)
  alter @m.xdut.xfac_0.xxor2.m0[l] = agauss(xor_m0l, 18n, 3)
  alter @m.xdut.xfac_0.xxor2.m1[w] = agauss(xor_m1w, 18n, 3)
  alter @m.xdut.xfac_0.xxor2.m1[l] = agauss(xor_m1l, 18n, 3)
  alter @m.xdut.xfac_0.xxor2.m2[w] = agauss(xor_m2w, 18n, 3)
  alter @m.xdut.xfac_0.xxor2.m2[l] = agauss(xor_m2l, 18n, 3)
  alter @m.xdut.xfac_0.xxor2.m3[w] = agauss(xor_m3w, 18n, 3)
  alter @m.xdut.xfac_0.xxor2.m3[l] = agauss(xor_m3l, 18n, 3)
  alter @m.xdut.xfac_0.xxor2.m4[w] = agauss(xor_m4w, 18n, 3)
  alter @m.xdut.xfac_0.xxor2.m4[l] = agauss(xor_m4l, 18n, 3)
  alter @m.xdut.xfac_0.xxor2.m5[w] = agauss(xor_m5w, 18n, 3)
  alter @m.xdut.xfac_0.xxor2.m5[l] = agauss(xor_m5l, 18n, 3)
  alter @m.xdut.xfac_0.xxor2.m6[w] = agauss(xor_m6w, 18n, 3)
  alter @m.xdut.xfac_0.xxor2.m6[l] = agauss(xor_m6l, 18n, 3)
  alter @m.xdut.xfac_0.xxor2.m7[w] = agauss(xor_m7w, 18n, 3)
  alter @m.xdut.xfac_0.xxor2.m7[l] = agauss(xor_m7l, 18n, 3)
  alter @m.xdut.xfac_0.xxor2.m8[w] = agauss(xor_m8w, 18n, 3)
  alter @m.xdut.xfac_0.xxor2.m8[l] = agauss(xor_m8l, 18n, 3)
  alter @m.xdut.xfac_0.xxor2.m9[w] = agauss(xor_m9w, 18n, 3)
  alter @m.xdut.xfac_0.xxor2.m9[l] = agauss(xor_m9l, 18n, 3)
  alter @m.xdut.xfac_0.xmux1.mo0[w] = agauss(mux_mo0w, 18n, 3)
  alter @m.xdut.xfac_0.xmux1.mo0[l] = agauss(mux_mo0l, 18n, 3)
  alter @m.xdut.xfac_0.xmux1.mo1[w] = agauss(mux_mo1w, 18n, 3)
  alter @m.xdut.xfac_0.xmux1.mo1[l] = agauss(mux_mo1l, 18n, 3)
  alter @m.xdut.xfac_0.xmux1.m0[w] = agauss(mux_m0w, 18n, 3)
  alter @m.xdut.xfac_0.xmux1.m0[l] = agauss(mux_m0l, 18n, 3)
  alter @m.xdut.xfac_0.xmux1.m1[w] = agauss(mux_m1w, 18n, 3)
  alter @m.xdut.xfac_0.xmux1.m1[l] = agauss(mux_m1l, 18n, 3)
  alter @m.xdut.xfac_0.xmux1.m2[w] = agauss(mux_m2w, 18n, 3)
  alter @m.xdut.xfac_0.xmux1.m2[l] = agauss(mux_m2l, 18n, 3)
  alter @m.xdut.xfac_0.xmux1.m3[w] = agauss(mux_m3w, 18n, 3)
  alter @m.xdut.xfac_0.xmux1.m3[l] = agauss(mux_m3l, 18n, 3)
  alter @m.xdut.xfac_0.xmux1.m4[w] = agauss(mux_m4w, 18n, 3)
  alter @m.xdut.xfac_0.xmux1.m4[l] = agauss(mux_m4l, 18n, 3)
  alter @m.xdut.xfac_0.xmux1.m5[w] = agauss(mux_m5w, 18n, 3)
  alter @m.xdut.xfac_0.xmux1.m5[l] = agauss(mux_m5l, 18n, 3)
  alter @m.xdut.xfac_0.xmux1.m6[w] = agauss(mux_m6w, 18n, 3)
  alter @m.xdut.xfac_0.xmux1.m6[l] = agauss(mux_m6l, 18n, 3)
  alter @m.xdut.xfac_0.xmux1.m7[w] = agauss(mux_m7w, 18n, 3)
  alter @m.xdut.xfac_0.xmux1.m7[l] = agauss(mux_m7l, 18n, 3)
  alter @m.xdut.xfac_0.xmux1.m8[w] = agauss(mux_m8w, 18n, 3)
  alter @m.xdut.xfac_0.xmux1.m8[l] = agauss(mux_m8l, 18n, 3)
  alter @m.xdut.xfac_0.xmux1.m9[w] = agauss(mux_m9w, 18n, 3)
  alter @m.xdut.xfac_0.xmux1.m9[l] = agauss(mux_m9l, 18n, 3)
  alter @m.xdut.xfac_1.xxor1.m0[w] = agauss(xor_m0w, 18n, 3)
  alter @m.xdut.xfac_1.xxor1.m0[l] = agauss(xor_m0l, 18n, 3)
  alter @m.xdut.xfac_1.xxor1.m1[w] = agauss(xor_m1w, 18n, 3)
  alter @m.xdut.xfac_1.xxor1.m1[l] = agauss(xor_m1l, 18n, 3)
  alter @m.xdut.xfac_1.xxor1.m2[w] = agauss(xor_m2w, 18n, 3)
  alter @m.xdut.xfac_1.xxor1.m2[l] = agauss(xor_m2l, 18n, 3)
  alter @m.xdut.xfac_1.xxor1.m3[w] = agauss(xor_m3w, 18n, 3)
  alter @m.xdut.xfac_1.xxor1.m3[l] = agauss(xor_m3l, 18n, 3)
  alter @m.xdut.xfac_1.xxor1.m4[w] = agauss(xor_m4w, 18n, 3)
  alter @m.xdut.xfac_1.xxor1.m4[l] = agauss(xor_m4l, 18n, 3)
  alter @m.xdut.xfac_1.xxor1.m5[w] = agauss(xor_m5w, 18n, 3)
  alter @m.xdut.xfac_1.xxor1.m5[l] = agauss(xor_m5l, 18n, 3)
  alter @m.xdut.xfac_1.xxor1.m6[w] = agauss(xor_m6w, 18n, 3)
  alter @m.xdut.xfac_1.xxor1.m6[l] = agauss(xor_m6l, 18n, 3)
  alter @m.xdut.xfac_1.xxor1.m7[w] = agauss(xor_m7w, 18n, 3)
  alter @m.xdut.xfac_1.xxor1.m7[l] = agauss(xor_m7l, 18n, 3)
  alter @m.xdut.xfac_1.xxor1.m8[w] = agauss(xor_m8w, 18n, 3)
  alter @m.xdut.xfac_1.xxor1.m8[l] = agauss(xor_m8l, 18n, 3)
  alter @m.xdut.xfac_1.xxor1.m9[w] = agauss(xor_m9w, 18n, 3)
  alter @m.xdut.xfac_1.xxor1.m9[l] = agauss(xor_m9l, 18n, 3)
  alter @m.xdut.xfac_1.xxor2.m0[w] = agauss(xor_m0w, 18n, 3)
  alter @m.xdut.xfac_1.xxor2.m0[l] = agauss(xor_m0l, 18n, 3)
  alter @m.xdut.xfac_1.xxor2.m1[w] = agauss(xor_m1w, 18n, 3)
  alter @m.xdut.xfac_1.xxor2.m1[l] = agauss(xor_m1l, 18n, 3)
  alter @m.xdut.xfac_1.xxor2.m2[w] = agauss(xor_m2w, 18n, 3)
  alter @m.xdut.xfac_1.xxor2.m2[l] = agauss(xor_m2l, 18n, 3)
  alter @m.xdut.xfac_1.xxor2.m3[w] = agauss(xor_m3w, 18n, 3)
  alter @m.xdut.xfac_1.xxor2.m3[l] = agauss(xor_m3l, 18n, 3)
  alter @m.xdut.xfac_1.xxor2.m4[w] = agauss(xor_m4w, 18n, 3)
  alter @m.xdut.xfac_1.xxor2.m4[l] = agauss(xor_m4l, 18n, 3)
  alter @m.xdut.xfac_1.xxor2.m5[w] = agauss(xor_m5w, 18n, 3)
  alter @m.xdut.xfac_1.xxor2.m5[l] = agauss(xor_m5l, 18n, 3)
  alter @m.xdut.xfac_1.xxor2.m6[w] = agauss(xor_m6w, 18n, 3)
  alter @m.xdut.xfac_1.xxor2.m6[l] = agauss(xor_m6l, 18n, 3)
  alter @m.xdut.xfac_1.xxor2.m7[w] = agauss(xor_m7w, 18n, 3)
  alter @m.xdut.xfac_1.xxor2.m7[l] = agauss(xor_m7l, 18n, 3)
  alter @m.xdut.xfac_1.xxor2.m8[w] = agauss(xor_m8w, 18n, 3)
  alter @m.xdut.xfac_1.xxor2.m8[l] = agauss(xor_m8l, 18n, 3)
  alter @m.xdut.xfac_1.xxor2.m9[w] = agauss(xor_m9w, 18n, 3)
  alter @m.xdut.xfac_1.xxor2.m9[l] = agauss(xor_m9l, 18n, 3)
  alter @m.xdut.xfac_1.xmux1.mo0[w] = agauss(mux_mo0w, 18n, 3)
  alter @m.xdut.xfac_1.xmux1.mo0[l] = agauss(mux_mo0l, 18n, 3)
  alter @m.xdut.xfac_1.xmux1.mo1[w] = agauss(mux_mo1w, 18n, 3)
  alter @m.xdut.xfac_1.xmux1.mo1[l] = agauss(mux_mo1l, 18n, 3)
  alter @m.xdut.xfac_1.xmux1.m0[w] = agauss(mux_m0w, 18n, 3)
  alter @m.xdut.xfac_1.xmux1.m0[l] = agauss(mux_m0l, 18n, 3)
  alter @m.xdut.xfac_1.xmux1.m1[w] = agauss(mux_m1w, 18n, 3)
  alter @m.xdut.xfac_1.xmux1.m1[l] = agauss(mux_m1l, 18n, 3)
  alter @m.xdut.xfac_1.xmux1.m2[w] = agauss(mux_m2w, 18n, 3)
  alter @m.xdut.xfac_1.xmux1.m2[l] = agauss(mux_m2l, 18n, 3)
  alter @m.xdut.xfac_1.xmux1.m3[w] = agauss(mux_m3w, 18n, 3)
  alter @m.xdut.xfac_1.xmux1.m3[l] = agauss(mux_m3l, 18n, 3)
  alter @m.xdut.xfac_1.xmux1.m4[w] = agauss(mux_m4w, 18n, 3)
  alter @m.xdut.xfac_1.xmux1.m4[l] = agauss(mux_m4l, 18n, 3)
  alter @m.xdut.xfac_1.xmux1.m5[w] = agauss(mux_m5w, 18n, 3)
  alter @m.xdut.xfac_1.xmux1.m5[l] = agauss(mux_m5l, 18n, 3)
  alter @m.xdut.xfac_1.xmux1.m6[w] = agauss(mux_m6w, 18n, 3)
  alter @m.xdut.xfac_1.xmux1.m6[l] = agauss(mux_m6l, 18n, 3)
  alter @m.xdut.xfac_1.xmux1.m7[w] = agauss(mux_m7w, 18n, 3)
  alter @m.xdut.xfac_1.xmux1.m7[l] = agauss(mux_m7l, 18n, 3)
  alter @m.xdut.xfac_1.xmux1.m8[w] = agauss(mux_m8w, 18n, 3)
  alter @m.xdut.xfac_1.xmux1.m8[l] = agauss(mux_m8l, 18n, 3)
  alter @m.xdut.xfac_1.xmux1.m9[w] = agauss(mux_m9w, 18n, 3)
  alter @m.xdut.xfac_1.xmux1.m9[l] = agauss(mux_m9l, 18n, 3)
  alter @m.xdut.xfad_0.xxor1.m0[w] = agauss(xor_m0w, 18n, 3)
  alter @m.xdut.xfad_0.xxor1.m0[l] = agauss(xor_m0l, 18n, 3)
  alter @m.xdut.xfad_0.xxor1.m1[w] = agauss(xor_m1w, 18n, 3)
  alter @m.xdut.xfad_0.xxor1.m1[l] = agauss(xor_m1l, 18n, 3)
  alter @m.xdut.xfad_0.xxor1.m2[w] = agauss(xor_m2w, 18n, 3)
  alter @m.xdut.xfad_0.xxor1.m2[l] = agauss(xor_m2l, 18n, 3)
  alter @m.xdut.xfad_0.xxor1.m3[w] = agauss(xor_m3w, 18n, 3)
  alter @m.xdut.xfad_0.xxor1.m3[l] = agauss(xor_m3l, 18n, 3)
  alter @m.xdut.xfad_0.xxor1.m4[w] = agauss(xor_m4w, 18n, 3)
  alter @m.xdut.xfad_0.xxor1.m4[l] = agauss(xor_m4l, 18n, 3)
  alter @m.xdut.xfad_0.xxor1.m5[w] = agauss(xor_m5w, 18n, 3)
  alter @m.xdut.xfad_0.xxor1.m5[l] = agauss(xor_m5l, 18n, 3)
  alter @m.xdut.xfad_0.xxor1.m6[w] = agauss(xor_m6w, 18n, 3)
  alter @m.xdut.xfad_0.xxor1.m6[l] = agauss(xor_m6l, 18n, 3)
  alter @m.xdut.xfad_0.xxor1.m7[w] = agauss(xor_m7w, 18n, 3)
  alter @m.xdut.xfad_0.xxor1.m7[l] = agauss(xor_m7l, 18n, 3)
  alter @m.xdut.xfad_0.xxor1.m8[w] = agauss(xor_m8w, 18n, 3)
  alter @m.xdut.xfad_0.xxor1.m8[l] = agauss(xor_m8l, 18n, 3)
  alter @m.xdut.xfad_0.xxor1.m9[w] = agauss(xor_m9w, 18n, 3)
  alter @m.xdut.xfad_0.xxor1.m9[l] = agauss(xor_m9l, 18n, 3)
  alter @m.xdut.xfad_0.xxor2.m0[w] = agauss(xor_m0w, 18n, 3)
  alter @m.xdut.xfad_0.xxor2.m0[l] = agauss(xor_m0l, 18n, 3)
  alter @m.xdut.xfad_0.xxor2.m1[w] = agauss(xor_m1w, 18n, 3)
  alter @m.xdut.xfad_0.xxor2.m1[l] = agauss(xor_m1l, 18n, 3)
  alter @m.xdut.xfad_0.xxor2.m2[w] = agauss(xor_m2w, 18n, 3)
  alter @m.xdut.xfad_0.xxor2.m2[l] = agauss(xor_m2l, 18n, 3)
  alter @m.xdut.xfad_0.xxor2.m3[w] = agauss(xor_m3w, 18n, 3)
  alter @m.xdut.xfad_0.xxor2.m3[l] = agauss(xor_m3l, 18n, 3)
  alter @m.xdut.xfad_0.xxor2.m4[w] = agauss(xor_m4w, 18n, 3)
  alter @m.xdut.xfad_0.xxor2.m4[l] = agauss(xor_m4l, 18n, 3)
  alter @m.xdut.xfad_0.xxor2.m5[w] = agauss(xor_m5w, 18n, 3)
  alter @m.xdut.xfad_0.xxor2.m5[l] = agauss(xor_m5l, 18n, 3)
  alter @m.xdut.xfad_0.xxor2.m6[w] = agauss(xor_m6w, 18n, 3)
  alter @m.xdut.xfad_0.xxor2.m6[l] = agauss(xor_m6l, 18n, 3)
  alter @m.xdut.xfad_0.xxor2.m7[w] = agauss(xor_m7w, 18n, 3)
  alter @m.xdut.xfad_0.xxor2.m7[l] = agauss(xor_m7l, 18n, 3)
  alter @m.xdut.xfad_0.xxor2.m8[w] = agauss(xor_m8w, 18n, 3)
  alter @m.xdut.xfad_0.xxor2.m8[l] = agauss(xor_m8l, 18n, 3)
  alter @m.xdut.xfad_0.xxor2.m9[w] = agauss(xor_m9w, 18n, 3)
  alter @m.xdut.xfad_0.xxor2.m9[l] = agauss(xor_m9l, 18n, 3)
  alter @m.xdut.xfad_0.xmux1.mo0[w] = agauss(mux_mo0w, 18n, 3)
  alter @m.xdut.xfad_0.xmux1.mo0[l] = agauss(mux_mo0l, 18n, 3)
  alter @m.xdut.xfad_0.xmux1.mo1[w] = agauss(mux_mo1w, 18n, 3)
  alter @m.xdut.xfad_0.xmux1.mo1[l] = agauss(mux_mo1l, 18n, 3)
  alter @m.xdut.xfad_0.xmux1.m0[w] = agauss(mux_m0w, 18n, 3)
  alter @m.xdut.xfad_0.xmux1.m0[l] = agauss(mux_m0l, 18n, 3)
  alter @m.xdut.xfad_0.xmux1.m1[w] = agauss(mux_m1w, 18n, 3)
  alter @m.xdut.xfad_0.xmux1.m1[l] = agauss(mux_m1l, 18n, 3)
  alter @m.xdut.xfad_0.xmux1.m2[w] = agauss(mux_m2w, 18n, 3)
  alter @m.xdut.xfad_0.xmux1.m2[l] = agauss(mux_m2l, 18n, 3)
  alter @m.xdut.xfad_0.xmux1.m3[w] = agauss(mux_m3w, 18n, 3)
  alter @m.xdut.xfad_0.xmux1.m3[l] = agauss(mux_m3l, 18n, 3)
  alter @m.xdut.xfad_0.xmux1.m4[w] = agauss(mux_m4w, 18n, 3)
  alter @m.xdut.xfad_0.xmux1.m4[l] = agauss(mux_m4l, 18n, 3)
  alter @m.xdut.xfad_0.xmux1.m5[w] = agauss(mux_m5w, 18n, 3)
  alter @m.xdut.xfad_0.xmux1.m5[l] = agauss(mux_m5l, 18n, 3)
  alter @m.xdut.xfad_0.xmux1.m6[w] = agauss(mux_m6w, 18n, 3)
  alter @m.xdut.xfad_0.xmux1.m6[l] = agauss(mux_m6l, 18n, 3)
  alter @m.xdut.xfad_0.xmux1.m7[w] = agauss(mux_m7w, 18n, 3)
  alter @m.xdut.xfad_0.xmux1.m7[l] = agauss(mux_m7l, 18n, 3)
  alter @m.xdut.xfad_0.xmux1.m8[w] = agauss(mux_m8w, 18n, 3)
  alter @m.xdut.xfad_0.xmux1.m8[l] = agauss(mux_m8l, 18n, 3)
  alter @m.xdut.xfad_0.xmux1.m9[w] = agauss(mux_m9w, 18n, 3)
  alter @m.xdut.xfad_0.xmux1.m9[l] = agauss(mux_m9l, 18n, 3)
  alter @m.xdut.xfad_1.xxor1.m0[w] = agauss(xor_m0w, 18n, 3)
  alter @m.xdut.xfad_1.xxor1.m0[l] = agauss(xor_m0l, 18n, 3)
  alter @m.xdut.xfad_1.xxor1.m1[w] = agauss(xor_m1w, 18n, 3)
  alter @m.xdut.xfad_1.xxor1.m1[l] = agauss(xor_m1l, 18n, 3)
  alter @m.xdut.xfad_1.xxor1.m2[w] = agauss(xor_m2w, 18n, 3)
  alter @m.xdut.xfad_1.xxor1.m2[l] = agauss(xor_m2l, 18n, 3)
  alter @m.xdut.xfad_1.xxor1.m3[w] = agauss(xor_m3w, 18n, 3)
  alter @m.xdut.xfad_1.xxor1.m3[l] = agauss(xor_m3l, 18n, 3)
  alter @m.xdut.xfad_1.xxor1.m4[w] = agauss(xor_m4w, 18n, 3)
  alter @m.xdut.xfad_1.xxor1.m4[l] = agauss(xor_m4l, 18n, 3)
  alter @m.xdut.xfad_1.xxor1.m5[w] = agauss(xor_m5w, 18n, 3)
  alter @m.xdut.xfad_1.xxor1.m5[l] = agauss(xor_m5l, 18n, 3)
  alter @m.xdut.xfad_1.xxor1.m6[w] = agauss(xor_m6w, 18n, 3)
  alter @m.xdut.xfad_1.xxor1.m6[l] = agauss(xor_m6l, 18n, 3)
  alter @m.xdut.xfad_1.xxor1.m7[w] = agauss(xor_m7w, 18n, 3)
  alter @m.xdut.xfad_1.xxor1.m7[l] = agauss(xor_m7l, 18n, 3)
  alter @m.xdut.xfad_1.xxor1.m8[w] = agauss(xor_m8w, 18n, 3)
  alter @m.xdut.xfad_1.xxor1.m8[l] = agauss(xor_m8l, 18n, 3)
  alter @m.xdut.xfad_1.xxor1.m9[w] = agauss(xor_m9w, 18n, 3)
  alter @m.xdut.xfad_1.xxor1.m9[l] = agauss(xor_m9l, 18n, 3)
  alter @m.xdut.xfad_1.xxor2.m0[w] = agauss(xor_m0w, 18n, 3)
  alter @m.xdut.xfad_1.xxor2.m0[l] = agauss(xor_m0l, 18n, 3)
  alter @m.xdut.xfad_1.xxor2.m1[w] = agauss(xor_m1w, 18n, 3)
  alter @m.xdut.xfad_1.xxor2.m1[l] = agauss(xor_m1l, 18n, 3)
  alter @m.xdut.xfad_1.xxor2.m2[w] = agauss(xor_m2w, 18n, 3)
  alter @m.xdut.xfad_1.xxor2.m2[l] = agauss(xor_m2l, 18n, 3)
  alter @m.xdut.xfad_1.xxor2.m3[w] = agauss(xor_m3w, 18n, 3)
  alter @m.xdut.xfad_1.xxor2.m3[l] = agauss(xor_m3l, 18n, 3)
  alter @m.xdut.xfad_1.xxor2.m4[w] = agauss(xor_m4w, 18n, 3)
  alter @m.xdut.xfad_1.xxor2.m4[l] = agauss(xor_m4l, 18n, 3)
  alter @m.xdut.xfad_1.xxor2.m5[w] = agauss(xor_m5w, 18n, 3)
  alter @m.xdut.xfad_1.xxor2.m5[l] = agauss(xor_m5l, 18n, 3)
  alter @m.xdut.xfad_1.xxor2.m6[w] = agauss(xor_m6w, 18n, 3)
  alter @m.xdut.xfad_1.xxor2.m6[l] = agauss(xor_m6l, 18n, 3)
  alter @m.xdut.xfad_1.xxor2.m7[w] = agauss(xor_m7w, 18n, 3)
  alter @m.xdut.xfad_1.xxor2.m7[l] = agauss(xor_m7l, 18n, 3)
  alter @m.xdut.xfad_1.xxor2.m8[w] = agauss(xor_m8w, 18n, 3)
  alter @m.xdut.xfad_1.xxor2.m8[l] = agauss(xor_m8l, 18n, 3)
  alter @m.xdut.xfad_1.xxor2.m9[w] = agauss(xor_m9w, 18n, 3)
  alter @m.xdut.xfad_1.xxor2.m9[l] = agauss(xor_m9l, 18n, 3)
  alter @m.xdut.xfad_1.xmux1.mo0[w] = agauss(mux_mo0w, 18n, 3)
  alter @m.xdut.xfad_1.xmux1.mo0[l] = agauss(mux_mo0l, 18n, 3)
  alter @m.xdut.xfad_1.xmux1.mo1[w] = agauss(mux_mo1w, 18n, 3)
  alter @m.xdut.xfad_1.xmux1.mo1[l] = agauss(mux_mo1l, 18n, 3)
  alter @m.xdut.xfad_1.xmux1.m0[w] = agauss(mux_m0w, 18n, 3)
  alter @m.xdut.xfad_1.xmux1.m0[l] = agauss(mux_m0l, 18n, 3)
  alter @m.xdut.xfad_1.xmux1.m1[w] = agauss(mux_m1w, 18n, 3)
  alter @m.xdut.xfad_1.xmux1.m1[l] = agauss(mux_m1l, 18n, 3)
  alter @m.xdut.xfad_1.xmux1.m2[w] = agauss(mux_m2w, 18n, 3)
  alter @m.xdut.xfad_1.xmux1.m2[l] = agauss(mux_m2l, 18n, 3)
  alter @m.xdut.xfad_1.xmux1.m3[w] = agauss(mux_m3w, 18n, 3)
  alter @m.xdut.xfad_1.xmux1.m3[l] = agauss(mux_m3l, 18n, 3)
  alter @m.xdut.xfad_1.xmux1.m4[w] = agauss(mux_m4w, 18n, 3)
  alter @m.xdut.xfad_1.xmux1.m4[l] = agauss(mux_m4l, 18n, 3)
  alter @m.xdut.xfad_1.xmux1.m5[w] = agauss(mux_m5w, 18n, 3)
  alter @m.xdut.xfad_1.xmux1.m5[l] = agauss(mux_m5l, 18n, 3)
  alter @m.xdut.xfad_1.xmux1.m6[w] = agauss(mux_m6w, 18n, 3)
  alter @m.xdut.xfad_1.xmux1.m6[l] = agauss(mux_m6l, 18n, 3)
  alter @m.xdut.xfad_1.xmux1.m7[w] = agauss(mux_m7w, 18n, 3)
  alter @m.xdut.xfad_1.xmux1.m7[l] = agauss(mux_m7l, 18n, 3)
  alter @m.xdut.xfad_1.xmux1.m8[w] = agauss(mux_m8w, 18n, 3)
  alter @m.xdut.xfad_1.xmux1.m8[l] = agauss(mux_m8l, 18n, 3)
  alter @m.xdut.xfad_1.xmux1.m9[w] = agauss(mux_m9w, 18n, 3)
  alter @m.xdut.xfad_1.xmux1.m9[l] = agauss(mux_m9l, 18n, 3)
  alter @m.xdut.xfae_0.xxor1.m0[w] = agauss(xor_m0w, 18n, 3)
  alter @m.xdut.xfae_0.xxor1.m0[l] = agauss(xor_m0l, 18n, 3)
  alter @m.xdut.xfae_0.xxor1.m1[w] = agauss(xor_m1w, 18n, 3)
  alter @m.xdut.xfae_0.xxor1.m1[l] = agauss(xor_m1l, 18n, 3)
  alter @m.xdut.xfae_0.xxor1.m2[w] = agauss(xor_m2w, 18n, 3)
  alter @m.xdut.xfae_0.xxor1.m2[l] = agauss(xor_m2l, 18n, 3)
  alter @m.xdut.xfae_0.xxor1.m3[w] = agauss(xor_m3w, 18n, 3)
  alter @m.xdut.xfae_0.xxor1.m3[l] = agauss(xor_m3l, 18n, 3)
  alter @m.xdut.xfae_0.xxor1.m4[w] = agauss(xor_m4w, 18n, 3)
  alter @m.xdut.xfae_0.xxor1.m4[l] = agauss(xor_m4l, 18n, 3)
  alter @m.xdut.xfae_0.xxor1.m5[w] = agauss(xor_m5w, 18n, 3)
  alter @m.xdut.xfae_0.xxor1.m5[l] = agauss(xor_m5l, 18n, 3)
  alter @m.xdut.xfae_0.xxor1.m6[w] = agauss(xor_m6w, 18n, 3)
  alter @m.xdut.xfae_0.xxor1.m6[l] = agauss(xor_m6l, 18n, 3)
  alter @m.xdut.xfae_0.xxor1.m7[w] = agauss(xor_m7w, 18n, 3)
  alter @m.xdut.xfae_0.xxor1.m7[l] = agauss(xor_m7l, 18n, 3)
  alter @m.xdut.xfae_0.xxor1.m8[w] = agauss(xor_m8w, 18n, 3)
  alter @m.xdut.xfae_0.xxor1.m8[l] = agauss(xor_m8l, 18n, 3)
  alter @m.xdut.xfae_0.xxor1.m9[w] = agauss(xor_m9w, 18n, 3)
  alter @m.xdut.xfae_0.xxor1.m9[l] = agauss(xor_m9l, 18n, 3)
  alter @m.xdut.xfae_0.xxor2.m0[w] = agauss(xor_m0w, 18n, 3)
  alter @m.xdut.xfae_0.xxor2.m0[l] = agauss(xor_m0l, 18n, 3)
  alter @m.xdut.xfae_0.xxor2.m1[w] = agauss(xor_m1w, 18n, 3)
  alter @m.xdut.xfae_0.xxor2.m1[l] = agauss(xor_m1l, 18n, 3)
  alter @m.xdut.xfae_0.xxor2.m2[w] = agauss(xor_m2w, 18n, 3)
  alter @m.xdut.xfae_0.xxor2.m2[l] = agauss(xor_m2l, 18n, 3)
  alter @m.xdut.xfae_0.xxor2.m3[w] = agauss(xor_m3w, 18n, 3)
  alter @m.xdut.xfae_0.xxor2.m3[l] = agauss(xor_m3l, 18n, 3)
  alter @m.xdut.xfae_0.xxor2.m4[w] = agauss(xor_m4w, 18n, 3)
  alter @m.xdut.xfae_0.xxor2.m4[l] = agauss(xor_m4l, 18n, 3)
  alter @m.xdut.xfae_0.xxor2.m5[w] = agauss(xor_m5w, 18n, 3)
  alter @m.xdut.xfae_0.xxor2.m5[l] = agauss(xor_m5l, 18n, 3)
  alter @m.xdut.xfae_0.xxor2.m6[w] = agauss(xor_m6w, 18n, 3)
  alter @m.xdut.xfae_0.xxor2.m6[l] = agauss(xor_m6l, 18n, 3)
  alter @m.xdut.xfae_0.xxor2.m7[w] = agauss(xor_m7w, 18n, 3)
  alter @m.xdut.xfae_0.xxor2.m7[l] = agauss(xor_m7l, 18n, 3)
  alter @m.xdut.xfae_0.xxor2.m8[w] = agauss(xor_m8w, 18n, 3)
  alter @m.xdut.xfae_0.xxor2.m8[l] = agauss(xor_m8l, 18n, 3)
  alter @m.xdut.xfae_0.xxor2.m9[w] = agauss(xor_m9w, 18n, 3)
  alter @m.xdut.xfae_0.xxor2.m9[l] = agauss(xor_m9l, 18n, 3)
  alter @m.xdut.xfae_0.xmux1.mo0[w] = agauss(mux_mo0w, 18n, 3)
  alter @m.xdut.xfae_0.xmux1.mo0[l] = agauss(mux_mo0l, 18n, 3)
  alter @m.xdut.xfae_0.xmux1.mo1[w] = agauss(mux_mo1w, 18n, 3)
  alter @m.xdut.xfae_0.xmux1.mo1[l] = agauss(mux_mo1l, 18n, 3)
  alter @m.xdut.xfae_0.xmux1.m0[w] = agauss(mux_m0w, 18n, 3)
  alter @m.xdut.xfae_0.xmux1.m0[l] = agauss(mux_m0l, 18n, 3)
  alter @m.xdut.xfae_0.xmux1.m1[w] = agauss(mux_m1w, 18n, 3)
  alter @m.xdut.xfae_0.xmux1.m1[l] = agauss(mux_m1l, 18n, 3)
  alter @m.xdut.xfae_0.xmux1.m2[w] = agauss(mux_m2w, 18n, 3)
  alter @m.xdut.xfae_0.xmux1.m2[l] = agauss(mux_m2l, 18n, 3)
  alter @m.xdut.xfae_0.xmux1.m3[w] = agauss(mux_m3w, 18n, 3)
  alter @m.xdut.xfae_0.xmux1.m3[l] = agauss(mux_m3l, 18n, 3)
  alter @m.xdut.xfae_0.xmux1.m4[w] = agauss(mux_m4w, 18n, 3)
  alter @m.xdut.xfae_0.xmux1.m4[l] = agauss(mux_m4l, 18n, 3)
  alter @m.xdut.xfae_0.xmux1.m5[w] = agauss(mux_m5w, 18n, 3)
  alter @m.xdut.xfae_0.xmux1.m5[l] = agauss(mux_m5l, 18n, 3)
  alter @m.xdut.xfae_0.xmux1.m6[w] = agauss(mux_m6w, 18n, 3)
  alter @m.xdut.xfae_0.xmux1.m6[l] = agauss(mux_m6l, 18n, 3)
  alter @m.xdut.xfae_0.xmux1.m7[w] = agauss(mux_m7w, 18n, 3)
  alter @m.xdut.xfae_0.xmux1.m7[l] = agauss(mux_m7l, 18n, 3)
  alter @m.xdut.xfae_0.xmux1.m8[w] = agauss(mux_m8w, 18n, 3)
  alter @m.xdut.xfae_0.xmux1.m8[l] = agauss(mux_m8l, 18n, 3)
  alter @m.xdut.xfae_0.xmux1.m9[w] = agauss(mux_m9w, 18n, 3)
  alter @m.xdut.xfae_0.xmux1.m9[l] = agauss(mux_m9l, 18n, 3)
  alter @m.xdut.xfae_1.xxor1.m0[w] = agauss(xor_m0w, 18n, 3)
  alter @m.xdut.xfae_1.xxor1.m0[l] = agauss(xor_m0l, 18n, 3)
  alter @m.xdut.xfae_1.xxor1.m1[w] = agauss(xor_m1w, 18n, 3)
  alter @m.xdut.xfae_1.xxor1.m1[l] = agauss(xor_m1l, 18n, 3)
  alter @m.xdut.xfae_1.xxor1.m2[w] = agauss(xor_m2w, 18n, 3)
  alter @m.xdut.xfae_1.xxor1.m2[l] = agauss(xor_m2l, 18n, 3)
  alter @m.xdut.xfae_1.xxor1.m3[w] = agauss(xor_m3w, 18n, 3)
  alter @m.xdut.xfae_1.xxor1.m3[l] = agauss(xor_m3l, 18n, 3)
  alter @m.xdut.xfae_1.xxor1.m4[w] = agauss(xor_m4w, 18n, 3)
  alter @m.xdut.xfae_1.xxor1.m4[l] = agauss(xor_m4l, 18n, 3)
  alter @m.xdut.xfae_1.xxor1.m5[w] = agauss(xor_m5w, 18n, 3)
  alter @m.xdut.xfae_1.xxor1.m5[l] = agauss(xor_m5l, 18n, 3)
  alter @m.xdut.xfae_1.xxor1.m6[w] = agauss(xor_m6w, 18n, 3)
  alter @m.xdut.xfae_1.xxor1.m6[l] = agauss(xor_m6l, 18n, 3)
  alter @m.xdut.xfae_1.xxor1.m7[w] = agauss(xor_m7w, 18n, 3)
  alter @m.xdut.xfae_1.xxor1.m7[l] = agauss(xor_m7l, 18n, 3)
  alter @m.xdut.xfae_1.xxor1.m8[w] = agauss(xor_m8w, 18n, 3)
  alter @m.xdut.xfae_1.xxor1.m8[l] = agauss(xor_m8l, 18n, 3)
  alter @m.xdut.xfae_1.xxor1.m9[w] = agauss(xor_m9w, 18n, 3)
  alter @m.xdut.xfae_1.xxor1.m9[l] = agauss(xor_m9l, 18n, 3)
  alter @m.xdut.xfae_1.xxor2.m0[w] = agauss(xor_m0w, 18n, 3)
  alter @m.xdut.xfae_1.xxor2.m0[l] = agauss(xor_m0l, 18n, 3)
  alter @m.xdut.xfae_1.xxor2.m1[w] = agauss(xor_m1w, 18n, 3)
  alter @m.xdut.xfae_1.xxor2.m1[l] = agauss(xor_m1l, 18n, 3)
  alter @m.xdut.xfae_1.xxor2.m2[w] = agauss(xor_m2w, 18n, 3)
  alter @m.xdut.xfae_1.xxor2.m2[l] = agauss(xor_m2l, 18n, 3)
  alter @m.xdut.xfae_1.xxor2.m3[w] = agauss(xor_m3w, 18n, 3)
  alter @m.xdut.xfae_1.xxor2.m3[l] = agauss(xor_m3l, 18n, 3)
  alter @m.xdut.xfae_1.xxor2.m4[w] = agauss(xor_m4w, 18n, 3)
  alter @m.xdut.xfae_1.xxor2.m4[l] = agauss(xor_m4l, 18n, 3)
  alter @m.xdut.xfae_1.xxor2.m5[w] = agauss(xor_m5w, 18n, 3)
  alter @m.xdut.xfae_1.xxor2.m5[l] = agauss(xor_m5l, 18n, 3)
  alter @m.xdut.xfae_1.xxor2.m6[w] = agauss(xor_m6w, 18n, 3)
  alter @m.xdut.xfae_1.xxor2.m6[l] = agauss(xor_m6l, 18n, 3)
  alter @m.xdut.xfae_1.xxor2.m7[w] = agauss(xor_m7w, 18n, 3)
  alter @m.xdut.xfae_1.xxor2.m7[l] = agauss(xor_m7l, 18n, 3)
  alter @m.xdut.xfae_1.xxor2.m8[w] = agauss(xor_m8w, 18n, 3)
  alter @m.xdut.xfae_1.xxor2.m8[l] = agauss(xor_m8l, 18n, 3)
  alter @m.xdut.xfae_1.xxor2.m9[w] = agauss(xor_m9w, 18n, 3)
  alter @m.xdut.xfae_1.xxor2.m9[l] = agauss(xor_m9l, 18n, 3)
  alter @m.xdut.xfae_1.xmux1.mo0[w] = agauss(mux_mo0w, 18n, 3)
  alter @m.xdut.xfae_1.xmux1.mo0[l] = agauss(mux_mo0l, 18n, 3)
  alter @m.xdut.xfae_1.xmux1.mo1[w] = agauss(mux_mo1w, 18n, 3)
  alter @m.xdut.xfae_1.xmux1.mo1[l] = agauss(mux_mo1l, 18n, 3)
  alter @m.xdut.xfae_1.xmux1.m0[w] = agauss(mux_m0w, 18n, 3)
  alter @m.xdut.xfae_1.xmux1.m0[l] = agauss(mux_m0l, 18n, 3)
  alter @m.xdut.xfae_1.xmux1.m1[w] = agauss(mux_m1w, 18n, 3)
  alter @m.xdut.xfae_1.xmux1.m1[l] = agauss(mux_m1l, 18n, 3)
  alter @m.xdut.xfae_1.xmux1.m2[w] = agauss(mux_m2w, 18n, 3)
  alter @m.xdut.xfae_1.xmux1.m2[l] = agauss(mux_m2l, 18n, 3)
  alter @m.xdut.xfae_1.xmux1.m3[w] = agauss(mux_m3w, 18n, 3)
  alter @m.xdut.xfae_1.xmux1.m3[l] = agauss(mux_m3l, 18n, 3)
  alter @m.xdut.xfae_1.xmux1.m4[w] = agauss(mux_m4w, 18n, 3)
  alter @m.xdut.xfae_1.xmux1.m4[l] = agauss(mux_m4l, 18n, 3)
  alter @m.xdut.xfae_1.xmux1.m5[w] = agauss(mux_m5w, 18n, 3)
  alter @m.xdut.xfae_1.xmux1.m5[l] = agauss(mux_m5l, 18n, 3)
  alter @m.xdut.xfae_1.xmux1.m6[w] = agauss(mux_m6w, 18n, 3)
  alter @m.xdut.xfae_1.xmux1.m6[l] = agauss(mux_m6l, 18n, 3)
  alter @m.xdut.xfae_1.xmux1.m7[w] = agauss(mux_m7w, 18n, 3)
  alter @m.xdut.xfae_1.xmux1.m7[l] = agauss(mux_m7l, 18n, 3)
  alter @m.xdut.xfae_1.xmux1.m8[w] = agauss(mux_m8w, 18n, 3)
  alter @m.xdut.xfae_1.xmux1.m8[l] = agauss(mux_m8l, 18n, 3)
  alter @m.xdut.xfae_1.xmux1.m9[w] = agauss(mux_m9w, 18n, 3)
  alter @m.xdut.xfae_1.xmux1.m9[l] = agauss(mux_m9l, 18n, 3)
  alter @m.xdut.xfaf_0.xxor1.m0[w] = agauss(xor_m0w, 18n, 3)
  alter @m.xdut.xfaf_0.xxor1.m0[l] = agauss(xor_m0l, 18n, 3)
  alter @m.xdut.xfaf_0.xxor1.m1[w] = agauss(xor_m1w, 18n, 3)
  alter @m.xdut.xfaf_0.xxor1.m1[l] = agauss(xor_m1l, 18n, 3)
  alter @m.xdut.xfaf_0.xxor1.m2[w] = agauss(xor_m2w, 18n, 3)
  alter @m.xdut.xfaf_0.xxor1.m2[l] = agauss(xor_m2l, 18n, 3)
  alter @m.xdut.xfaf_0.xxor1.m3[w] = agauss(xor_m3w, 18n, 3)
  alter @m.xdut.xfaf_0.xxor1.m3[l] = agauss(xor_m3l, 18n, 3)
  alter @m.xdut.xfaf_0.xxor1.m4[w] = agauss(xor_m4w, 18n, 3)
  alter @m.xdut.xfaf_0.xxor1.m4[l] = agauss(xor_m4l, 18n, 3)
  alter @m.xdut.xfaf_0.xxor1.m5[w] = agauss(xor_m5w, 18n, 3)
  alter @m.xdut.xfaf_0.xxor1.m5[l] = agauss(xor_m5l, 18n, 3)
  alter @m.xdut.xfaf_0.xxor1.m6[w] = agauss(xor_m6w, 18n, 3)
  alter @m.xdut.xfaf_0.xxor1.m6[l] = agauss(xor_m6l, 18n, 3)
  alter @m.xdut.xfaf_0.xxor1.m7[w] = agauss(xor_m7w, 18n, 3)
  alter @m.xdut.xfaf_0.xxor1.m7[l] = agauss(xor_m7l, 18n, 3)
  alter @m.xdut.xfaf_0.xxor1.m8[w] = agauss(xor_m8w, 18n, 3)
  alter @m.xdut.xfaf_0.xxor1.m8[l] = agauss(xor_m8l, 18n, 3)
  alter @m.xdut.xfaf_0.xxor1.m9[w] = agauss(xor_m9w, 18n, 3)
  alter @m.xdut.xfaf_0.xxor1.m9[l] = agauss(xor_m9l, 18n, 3)
  alter @m.xdut.xfaf_0.xxor2.m0[w] = agauss(xor_m0w, 18n, 3)
  alter @m.xdut.xfaf_0.xxor2.m0[l] = agauss(xor_m0l, 18n, 3)
  alter @m.xdut.xfaf_0.xxor2.m1[w] = agauss(xor_m1w, 18n, 3)
  alter @m.xdut.xfaf_0.xxor2.m1[l] = agauss(xor_m1l, 18n, 3)
  alter @m.xdut.xfaf_0.xxor2.m2[w] = agauss(xor_m2w, 18n, 3)
  alter @m.xdut.xfaf_0.xxor2.m2[l] = agauss(xor_m2l, 18n, 3)
  alter @m.xdut.xfaf_0.xxor2.m3[w] = agauss(xor_m3w, 18n, 3)
  alter @m.xdut.xfaf_0.xxor2.m3[l] = agauss(xor_m3l, 18n, 3)
  alter @m.xdut.xfaf_0.xxor2.m4[w] = agauss(xor_m4w, 18n, 3)
  alter @m.xdut.xfaf_0.xxor2.m4[l] = agauss(xor_m4l, 18n, 3)
  alter @m.xdut.xfaf_0.xxor2.m5[w] = agauss(xor_m5w, 18n, 3)
  alter @m.xdut.xfaf_0.xxor2.m5[l] = agauss(xor_m5l, 18n, 3)
  alter @m.xdut.xfaf_0.xxor2.m6[w] = agauss(xor_m6w, 18n, 3)
  alter @m.xdut.xfaf_0.xxor2.m6[l] = agauss(xor_m6l, 18n, 3)
  alter @m.xdut.xfaf_0.xxor2.m7[w] = agauss(xor_m7w, 18n, 3)
  alter @m.xdut.xfaf_0.xxor2.m7[l] = agauss(xor_m7l, 18n, 3)
  alter @m.xdut.xfaf_0.xxor2.m8[w] = agauss(xor_m8w, 18n, 3)
  alter @m.xdut.xfaf_0.xxor2.m8[l] = agauss(xor_m8l, 18n, 3)
  alter @m.xdut.xfaf_0.xxor2.m9[w] = agauss(xor_m9w, 18n, 3)
  alter @m.xdut.xfaf_0.xxor2.m9[l] = agauss(xor_m9l, 18n, 3)
  alter @m.xdut.xfaf_0.xmux1.mo0[w] = agauss(mux_mo0w, 18n, 3)
  alter @m.xdut.xfaf_0.xmux1.mo0[l] = agauss(mux_mo0l, 18n, 3)
  alter @m.xdut.xfaf_0.xmux1.mo1[w] = agauss(mux_mo1w, 18n, 3)
  alter @m.xdut.xfaf_0.xmux1.mo1[l] = agauss(mux_mo1l, 18n, 3)
  alter @m.xdut.xfaf_0.xmux1.m0[w] = agauss(mux_m0w, 18n, 3)
  alter @m.xdut.xfaf_0.xmux1.m0[l] = agauss(mux_m0l, 18n, 3)
  alter @m.xdut.xfaf_0.xmux1.m1[w] = agauss(mux_m1w, 18n, 3)
  alter @m.xdut.xfaf_0.xmux1.m1[l] = agauss(mux_m1l, 18n, 3)
  alter @m.xdut.xfaf_0.xmux1.m2[w] = agauss(mux_m2w, 18n, 3)
  alter @m.xdut.xfaf_0.xmux1.m2[l] = agauss(mux_m2l, 18n, 3)
  alter @m.xdut.xfaf_0.xmux1.m3[w] = agauss(mux_m3w, 18n, 3)
  alter @m.xdut.xfaf_0.xmux1.m3[l] = agauss(mux_m3l, 18n, 3)
  alter @m.xdut.xfaf_0.xmux1.m4[w] = agauss(mux_m4w, 18n, 3)
  alter @m.xdut.xfaf_0.xmux1.m4[l] = agauss(mux_m4l, 18n, 3)
  alter @m.xdut.xfaf_0.xmux1.m5[w] = agauss(mux_m5w, 18n, 3)
  alter @m.xdut.xfaf_0.xmux1.m5[l] = agauss(mux_m5l, 18n, 3)
  alter @m.xdut.xfaf_0.xmux1.m6[w] = agauss(mux_m6w, 18n, 3)
  alter @m.xdut.xfaf_0.xmux1.m6[l] = agauss(mux_m6l, 18n, 3)
  alter @m.xdut.xfaf_0.xmux1.m7[w] = agauss(mux_m7w, 18n, 3)
  alter @m.xdut.xfaf_0.xmux1.m7[l] = agauss(mux_m7l, 18n, 3)
  alter @m.xdut.xfaf_0.xmux1.m8[w] = agauss(mux_m8w, 18n, 3)
  alter @m.xdut.xfaf_0.xmux1.m8[l] = agauss(mux_m8l, 18n, 3)
  alter @m.xdut.xfaf_0.xmux1.m9[w] = agauss(mux_m9w, 18n, 3)
  alter @m.xdut.xfaf_0.xmux1.m9[l] = agauss(mux_m9l, 18n, 3)
  alter @m.xdut.xfaf_1.xxor1.m0[w] = agauss(xor_m0w, 18n, 3)
  alter @m.xdut.xfaf_1.xxor1.m0[l] = agauss(xor_m0l, 18n, 3)
  alter @m.xdut.xfaf_1.xxor1.m1[w] = agauss(xor_m1w, 18n, 3)
  alter @m.xdut.xfaf_1.xxor1.m1[l] = agauss(xor_m1l, 18n, 3)
  alter @m.xdut.xfaf_1.xxor1.m2[w] = agauss(xor_m2w, 18n, 3)
  alter @m.xdut.xfaf_1.xxor1.m2[l] = agauss(xor_m2l, 18n, 3)
  alter @m.xdut.xfaf_1.xxor1.m3[w] = agauss(xor_m3w, 18n, 3)
  alter @m.xdut.xfaf_1.xxor1.m3[l] = agauss(xor_m3l, 18n, 3)
  alter @m.xdut.xfaf_1.xxor1.m4[w] = agauss(xor_m4w, 18n, 3)
  alter @m.xdut.xfaf_1.xxor1.m4[l] = agauss(xor_m4l, 18n, 3)
  alter @m.xdut.xfaf_1.xxor1.m5[w] = agauss(xor_m5w, 18n, 3)
  alter @m.xdut.xfaf_1.xxor1.m5[l] = agauss(xor_m5l, 18n, 3)
  alter @m.xdut.xfaf_1.xxor1.m6[w] = agauss(xor_m6w, 18n, 3)
  alter @m.xdut.xfaf_1.xxor1.m6[l] = agauss(xor_m6l, 18n, 3)
  alter @m.xdut.xfaf_1.xxor1.m7[w] = agauss(xor_m7w, 18n, 3)
  alter @m.xdut.xfaf_1.xxor1.m7[l] = agauss(xor_m7l, 18n, 3)
  alter @m.xdut.xfaf_1.xxor1.m8[w] = agauss(xor_m8w, 18n, 3)
  alter @m.xdut.xfaf_1.xxor1.m8[l] = agauss(xor_m8l, 18n, 3)
  alter @m.xdut.xfaf_1.xxor1.m9[w] = agauss(xor_m9w, 18n, 3)
  alter @m.xdut.xfaf_1.xxor1.m9[l] = agauss(xor_m9l, 18n, 3)
  alter @m.xdut.xfaf_1.xxor2.m0[w] = agauss(xor_m0w, 18n, 3)
  alter @m.xdut.xfaf_1.xxor2.m0[l] = agauss(xor_m0l, 18n, 3)
  alter @m.xdut.xfaf_1.xxor2.m1[w] = agauss(xor_m1w, 18n, 3)
  alter @m.xdut.xfaf_1.xxor2.m1[l] = agauss(xor_m1l, 18n, 3)
  alter @m.xdut.xfaf_1.xxor2.m2[w] = agauss(xor_m2w, 18n, 3)
  alter @m.xdut.xfaf_1.xxor2.m2[l] = agauss(xor_m2l, 18n, 3)
  alter @m.xdut.xfaf_1.xxor2.m3[w] = agauss(xor_m3w, 18n, 3)
  alter @m.xdut.xfaf_1.xxor2.m3[l] = agauss(xor_m3l, 18n, 3)
  alter @m.xdut.xfaf_1.xxor2.m4[w] = agauss(xor_m4w, 18n, 3)
  alter @m.xdut.xfaf_1.xxor2.m4[l] = agauss(xor_m4l, 18n, 3)
  alter @m.xdut.xfaf_1.xxor2.m5[w] = agauss(xor_m5w, 18n, 3)
  alter @m.xdut.xfaf_1.xxor2.m5[l] = agauss(xor_m5l, 18n, 3)
  alter @m.xdut.xfaf_1.xxor2.m6[w] = agauss(xor_m6w, 18n, 3)
  alter @m.xdut.xfaf_1.xxor2.m6[l] = agauss(xor_m6l, 18n, 3)
  alter @m.xdut.xfaf_1.xxor2.m7[w] = agauss(xor_m7w, 18n, 3)
  alter @m.xdut.xfaf_1.xxor2.m7[l] = agauss(xor_m7l, 18n, 3)
  alter @m.xdut.xfaf_1.xxor2.m8[w] = agauss(xor_m8w, 18n, 3)
  alter @m.xdut.xfaf_1.xxor2.m8[l] = agauss(xor_m8l, 18n, 3)
  alter @m.xdut.xfaf_1.xxor2.m9[w] = agauss(xor_m9w, 18n, 3)
  alter @m.xdut.xfaf_1.xxor2.m9[l] = agauss(xor_m9l, 18n, 3)
  alter @m.xdut.xfaf_1.xmux1.mo0[w] = agauss(mux_mo0w, 18n, 3)
  alter @m.xdut.xfaf_1.xmux1.mo0[l] = agauss(mux_mo0l, 18n, 3)
  alter @m.xdut.xfaf_1.xmux1.mo1[w] = agauss(mux_mo1w, 18n, 3)
  alter @m.xdut.xfaf_1.xmux1.mo1[l] = agauss(mux_mo1l, 18n, 3)
  alter @m.xdut.xfaf_1.xmux1.m0[w] = agauss(mux_m0w, 18n, 3)
  alter @m.xdut.xfaf_1.xmux1.m0[l] = agauss(mux_m0l, 18n, 3)
  alter @m.xdut.xfaf_1.xmux1.m1[w] = agauss(mux_m1w, 18n, 3)
  alter @m.xdut.xfaf_1.xmux1.m1[l] = agauss(mux_m1l, 18n, 3)
  alter @m.xdut.xfaf_1.xmux1.m2[w] = agauss(mux_m2w, 18n, 3)
  alter @m.xdut.xfaf_1.xmux1.m2[l] = agauss(mux_m2l, 18n, 3)
  alter @m.xdut.xfaf_1.xmux1.m3[w] = agauss(mux_m3w, 18n, 3)
  alter @m.xdut.xfaf_1.xmux1.m3[l] = agauss(mux_m3l, 18n, 3)
  alter @m.xdut.xfaf_1.xmux1.m4[w] = agauss(mux_m4w, 18n, 3)
  alter @m.xdut.xfaf_1.xmux1.m4[l] = agauss(mux_m4l, 18n, 3)
  alter @m.xdut.xfaf_1.xmux1.m5[w] = agauss(mux_m5w, 18n, 3)
  alter @m.xdut.xfaf_1.xmux1.m5[l] = agauss(mux_m5l, 18n, 3)
  alter @m.xdut.xfaf_1.xmux1.m6[w] = agauss(mux_m6w, 18n, 3)
  alter @m.xdut.xfaf_1.xmux1.m6[l] = agauss(mux_m6l, 18n, 3)
  alter @m.xdut.xfaf_1.xmux1.m7[w] = agauss(mux_m7w, 18n, 3)
  alter @m.xdut.xfaf_1.xmux1.m7[l] = agauss(mux_m7l, 18n, 3)
  alter @m.xdut.xfaf_1.xmux1.m8[w] = agauss(mux_m8w, 18n, 3)
  alter @m.xdut.xfaf_1.xmux1.m8[l] = agauss(mux_m8l, 18n, 3)
  alter @m.xdut.xfaf_1.xmux1.m9[w] = agauss(mux_m9w, 18n, 3)
  alter @m.xdut.xfaf_1.xmux1.m9[l] = agauss(mux_m9l, 18n, 3)
  alter @m.xdut.xmux_s0.mo0[w] = agauss(mux_mo0w, 18n, 3)
  alter @m.xdut.xmux_s0.mo0[l] = agauss(mux_mo0l, 18n, 3)
  alter @m.xdut.xmux_s0.mo1[w] = agauss(mux_mo1w, 18n, 3)
  alter @m.xdut.xmux_s0.mo1[l] = agauss(mux_mo1l, 18n, 3)
  alter @m.xdut.xmux_s0.m0[w] = agauss(mux_m0w, 18n, 3)
  alter @m.xdut.xmux_s0.m0[l] = agauss(mux_m0l, 18n, 3)
  alter @m.xdut.xmux_s0.m1[w] = agauss(mux_m1w, 18n, 3)
  alter @m.xdut.xmux_s0.m1[l] = agauss(mux_m1l, 18n, 3)
  alter @m.xdut.xmux_s0.m2[w] = agauss(mux_m2w, 18n, 3)
  alter @m.xdut.xmux_s0.m2[l] = agauss(mux_m2l, 18n, 3)
  alter @m.xdut.xmux_s0.m3[w] = agauss(mux_m3w, 18n, 3)
  alter @m.xdut.xmux_s0.m3[l] = agauss(mux_m3l, 18n, 3)
  alter @m.xdut.xmux_s0.m4[w] = agauss(mux_m4w, 18n, 3)
  alter @m.xdut.xmux_s0.m4[l] = agauss(mux_m4l, 18n, 3)
  alter @m.xdut.xmux_s0.m5[w] = agauss(mux_m5w, 18n, 3)
  alter @m.xdut.xmux_s0.m5[l] = agauss(mux_m5l, 18n, 3)
  alter @m.xdut.xmux_s0.m6[w] = agauss(mux_m6w, 18n, 3)
  alter @m.xdut.xmux_s0.m6[l] = agauss(mux_m6l, 18n, 3)
  alter @m.xdut.xmux_s0.m7[w] = agauss(mux_m7w, 18n, 3)
  alter @m.xdut.xmux_s0.m7[l] = agauss(mux_m7l, 18n, 3)
  alter @m.xdut.xmux_s0.m8[w] = agauss(mux_m8w, 18n, 3)
  alter @m.xdut.xmux_s0.m8[l] = agauss(mux_m8l, 18n, 3)
  alter @m.xdut.xmux_s0.m9[w] = agauss(mux_m9w, 18n, 3)
  alter @m.xdut.xmux_s0.m9[l] = agauss(mux_m9l, 18n, 3)
  alter @m.xdut.xmux_s1.mo0[w] = agauss(mux_mo0w, 18n, 3)
  alter @m.xdut.xmux_s1.mo0[l] = agauss(mux_mo0l, 18n, 3)
  alter @m.xdut.xmux_s1.mo1[w] = agauss(mux_mo1w, 18n, 3)
  alter @m.xdut.xmux_s1.mo1[l] = agauss(mux_mo1l, 18n, 3)
  alter @m.xdut.xmux_s1.m0[w] = agauss(mux_m0w, 18n, 3)
  alter @m.xdut.xmux_s1.m0[l] = agauss(mux_m0l, 18n, 3)
  alter @m.xdut.xmux_s1.m1[w] = agauss(mux_m1w, 18n, 3)
  alter @m.xdut.xmux_s1.m1[l] = agauss(mux_m1l, 18n, 3)
  alter @m.xdut.xmux_s1.m2[w] = agauss(mux_m2w, 18n, 3)
  alter @m.xdut.xmux_s1.m2[l] = agauss(mux_m2l, 18n, 3)
  alter @m.xdut.xmux_s1.m3[w] = agauss(mux_m3w, 18n, 3)
  alter @m.xdut.xmux_s1.m3[l] = agauss(mux_m3l, 18n, 3)
  alter @m.xdut.xmux_s1.m4[w] = agauss(mux_m4w, 18n, 3)
  alter @m.xdut.xmux_s1.m4[l] = agauss(mux_m4l, 18n, 3)
  alter @m.xdut.xmux_s1.m5[w] = agauss(mux_m5w, 18n, 3)
  alter @m.xdut.xmux_s1.m5[l] = agauss(mux_m5l, 18n, 3)
  alter @m.xdut.xmux_s1.m6[w] = agauss(mux_m6w, 18n, 3)
  alter @m.xdut.xmux_s1.m6[l] = agauss(mux_m6l, 18n, 3)
  alter @m.xdut.xmux_s1.m7[w] = agauss(mux_m7w, 18n, 3)
  alter @m.xdut.xmux_s1.m7[l] = agauss(mux_m7l, 18n, 3)
  alter @m.xdut.xmux_s1.m8[w] = agauss(mux_m8w, 18n, 3)
  alter @m.xdut.xmux_s1.m8[l] = agauss(mux_m8l, 18n, 3)
  alter @m.xdut.xmux_s1.m9[w] = agauss(mux_m9w, 18n, 3)
  alter @m.xdut.xmux_s1.m9[l] = agauss(mux_m9l, 18n, 3)
  alter @m.xdut.xmux_s2.mo0[w] = agauss(mux_mo0w, 18n, 3)
  alter @m.xdut.xmux_s2.mo0[l] = agauss(mux_mo0l, 18n, 3)
  alter @m.xdut.xmux_s2.mo1[w] = agauss(mux_mo1w, 18n, 3)
  alter @m.xdut.xmux_s2.mo1[l] = agauss(mux_mo1l, 18n, 3)
  alter @m.xdut.xmux_s2.m0[w] = agauss(mux_m0w, 18n, 3)
  alter @m.xdut.xmux_s2.m0[l] = agauss(mux_m0l, 18n, 3)
  alter @m.xdut.xmux_s2.m1[w] = agauss(mux_m1w, 18n, 3)
  alter @m.xdut.xmux_s2.m1[l] = agauss(mux_m1l, 18n, 3)
  alter @m.xdut.xmux_s2.m2[w] = agauss(mux_m2w, 18n, 3)
  alter @m.xdut.xmux_s2.m2[l] = agauss(mux_m2l, 18n, 3)
  alter @m.xdut.xmux_s2.m3[w] = agauss(mux_m3w, 18n, 3)
  alter @m.xdut.xmux_s2.m3[l] = agauss(mux_m3l, 18n, 3)
  alter @m.xdut.xmux_s2.m4[w] = agauss(mux_m4w, 18n, 3)
  alter @m.xdut.xmux_s2.m4[l] = agauss(mux_m4l, 18n, 3)
  alter @m.xdut.xmux_s2.m5[w] = agauss(mux_m5w, 18n, 3)
  alter @m.xdut.xmux_s2.m5[l] = agauss(mux_m5l, 18n, 3)
  alter @m.xdut.xmux_s2.m6[w] = agauss(mux_m6w, 18n, 3)
  alter @m.xdut.xmux_s2.m6[l] = agauss(mux_m6l, 18n, 3)
  alter @m.xdut.xmux_s2.m7[w] = agauss(mux_m7w, 18n, 3)
  alter @m.xdut.xmux_s2.m7[l] = agauss(mux_m7l, 18n, 3)
  alter @m.xdut.xmux_s2.m8[w] = agauss(mux_m8w, 18n, 3)
  alter @m.xdut.xmux_s2.m8[l] = agauss(mux_m8l, 18n, 3)
  alter @m.xdut.xmux_s2.m9[w] = agauss(mux_m9w, 18n, 3)
  alter @m.xdut.xmux_s2.m9[l] = agauss(mux_m9l, 18n, 3)
  alter @m.xdut.xmux_s3.mo0[w] = agauss(mux_mo0w, 18n, 3)
  alter @m.xdut.xmux_s3.mo0[l] = agauss(mux_mo0l, 18n, 3)
  alter @m.xdut.xmux_s3.mo1[w] = agauss(mux_mo1w, 18n, 3)
  alter @m.xdut.xmux_s3.mo1[l] = agauss(mux_mo1l, 18n, 3)
  alter @m.xdut.xmux_s3.m0[w] = agauss(mux_m0w, 18n, 3)
  alter @m.xdut.xmux_s3.m0[l] = agauss(mux_m0l, 18n, 3)
  alter @m.xdut.xmux_s3.m1[w] = agauss(mux_m1w, 18n, 3)
  alter @m.xdut.xmux_s3.m1[l] = agauss(mux_m1l, 18n, 3)
  alter @m.xdut.xmux_s3.m2[w] = agauss(mux_m2w, 18n, 3)
  alter @m.xdut.xmux_s3.m2[l] = agauss(mux_m2l, 18n, 3)
  alter @m.xdut.xmux_s3.m3[w] = agauss(mux_m3w, 18n, 3)
  alter @m.xdut.xmux_s3.m3[l] = agauss(mux_m3l, 18n, 3)
  alter @m.xdut.xmux_s3.m4[w] = agauss(mux_m4w, 18n, 3)
  alter @m.xdut.xmux_s3.m4[l] = agauss(mux_m4l, 18n, 3)
  alter @m.xdut.xmux_s3.m5[w] = agauss(mux_m5w, 18n, 3)
  alter @m.xdut.xmux_s3.m5[l] = agauss(mux_m5l, 18n, 3)
  alter @m.xdut.xmux_s3.m6[w] = agauss(mux_m6w, 18n, 3)
  alter @m.xdut.xmux_s3.m6[l] = agauss(mux_m6l, 18n, 3)
  alter @m.xdut.xmux_s3.m7[w] = agauss(mux_m7w, 18n, 3)
  alter @m.xdut.xmux_s3.m7[l] = agauss(mux_m7l, 18n, 3)
  alter @m.xdut.xmux_s3.m8[w] = agauss(mux_m8w, 18n, 3)
  alter @m.xdut.xmux_s3.m8[l] = agauss(mux_m8l, 18n, 3)
  alter @m.xdut.xmux_s3.m9[w] = agauss(mux_m9w, 18n, 3)
  alter @m.xdut.xmux_s3.m9[l] = agauss(mux_m9l, 18n, 3)
  alter @m.xdut.xmux_s4.mo0[w] = agauss(mux_mo0w, 18n, 3)
  alter @m.xdut.xmux_s4.mo0[l] = agauss(mux_mo0l, 18n, 3)
  alter @m.xdut.xmux_s4.mo1[w] = agauss(mux_mo1w, 18n, 3)
  alter @m.xdut.xmux_s4.mo1[l] = agauss(mux_mo1l, 18n, 3)
  alter @m.xdut.xmux_s4.m0[w] = agauss(mux_m0w, 18n, 3)
  alter @m.xdut.xmux_s4.m0[l] = agauss(mux_m0l, 18n, 3)
  alter @m.xdut.xmux_s4.m1[w] = agauss(mux_m1w, 18n, 3)
  alter @m.xdut.xmux_s4.m1[l] = agauss(mux_m1l, 18n, 3)
  alter @m.xdut.xmux_s4.m2[w] = agauss(mux_m2w, 18n, 3)
  alter @m.xdut.xmux_s4.m2[l] = agauss(mux_m2l, 18n, 3)
  alter @m.xdut.xmux_s4.m3[w] = agauss(mux_m3w, 18n, 3)
  alter @m.xdut.xmux_s4.m3[l] = agauss(mux_m3l, 18n, 3)
  alter @m.xdut.xmux_s4.m4[w] = agauss(mux_m4w, 18n, 3)
  alter @m.xdut.xmux_s4.m4[l] = agauss(mux_m4l, 18n, 3)
  alter @m.xdut.xmux_s4.m5[w] = agauss(mux_m5w, 18n, 3)
  alter @m.xdut.xmux_s4.m5[l] = agauss(mux_m5l, 18n, 3)
  alter @m.xdut.xmux_s4.m6[w] = agauss(mux_m6w, 18n, 3)
  alter @m.xdut.xmux_s4.m6[l] = agauss(mux_m6l, 18n, 3)
  alter @m.xdut.xmux_s4.m7[w] = agauss(mux_m7w, 18n, 3)
  alter @m.xdut.xmux_s4.m7[l] = agauss(mux_m7l, 18n, 3)
  alter @m.xdut.xmux_s4.m8[w] = agauss(mux_m8w, 18n, 3)
  alter @m.xdut.xmux_s4.m8[l] = agauss(mux_m8l, 18n, 3)
  alter @m.xdut.xmux_s4.m9[w] = agauss(mux_m9w, 18n, 3)
  alter @m.xdut.xmux_s4.m9[l] = agauss(mux_m9l, 18n, 3)
  alter @m.xdut.xmux_s5.mo0[w] = agauss(mux_mo0w, 18n, 3)
  alter @m.xdut.xmux_s5.mo0[l] = agauss(mux_mo0l, 18n, 3)
  alter @m.xdut.xmux_s5.mo1[w] = agauss(mux_mo1w, 18n, 3)
  alter @m.xdut.xmux_s5.mo1[l] = agauss(mux_mo1l, 18n, 3)
  alter @m.xdut.xmux_s5.m0[w] = agauss(mux_m0w, 18n, 3)
  alter @m.xdut.xmux_s5.m0[l] = agauss(mux_m0l, 18n, 3)
  alter @m.xdut.xmux_s5.m1[w] = agauss(mux_m1w, 18n, 3)
  alter @m.xdut.xmux_s5.m1[l] = agauss(mux_m1l, 18n, 3)
  alter @m.xdut.xmux_s5.m2[w] = agauss(mux_m2w, 18n, 3)
  alter @m.xdut.xmux_s5.m2[l] = agauss(mux_m2l, 18n, 3)
  alter @m.xdut.xmux_s5.m3[w] = agauss(mux_m3w, 18n, 3)
  alter @m.xdut.xmux_s5.m3[l] = agauss(mux_m3l, 18n, 3)
  alter @m.xdut.xmux_s5.m4[w] = agauss(mux_m4w, 18n, 3)
  alter @m.xdut.xmux_s5.m4[l] = agauss(mux_m4l, 18n, 3)
  alter @m.xdut.xmux_s5.m5[w] = agauss(mux_m5w, 18n, 3)
  alter @m.xdut.xmux_s5.m5[l] = agauss(mux_m5l, 18n, 3)
  alter @m.xdut.xmux_s5.m6[w] = agauss(mux_m6w, 18n, 3)
  alter @m.xdut.xmux_s5.m6[l] = agauss(mux_m6l, 18n, 3)
  alter @m.xdut.xmux_s5.m7[w] = agauss(mux_m7w, 18n, 3)
  alter @m.xdut.xmux_s5.m7[l] = agauss(mux_m7l, 18n, 3)
  alter @m.xdut.xmux_s5.m8[w] = agauss(mux_m8w, 18n, 3)
  alter @m.xdut.xmux_s5.m8[l] = agauss(mux_m8l, 18n, 3)
  alter @m.xdut.xmux_s5.m9[w] = agauss(mux_m9w, 18n, 3)
  alter @m.xdut.xmux_s5.m9[l] = agauss(mux_m9l, 18n, 3)
  alter @m.xdut.xmux_s6.mo0[w] = agauss(mux_mo0w, 18n, 3)
  alter @m.xdut.xmux_s6.mo0[l] = agauss(mux_mo0l, 18n, 3)
  alter @m.xdut.xmux_s6.mo1[w] = agauss(mux_mo1w, 18n, 3)
  alter @m.xdut.xmux_s6.mo1[l] = agauss(mux_mo1l, 18n, 3)
  alter @m.xdut.xmux_s6.m0[w] = agauss(mux_m0w, 18n, 3)
  alter @m.xdut.xmux_s6.m0[l] = agauss(mux_m0l, 18n, 3)
  alter @m.xdut.xmux_s6.m1[w] = agauss(mux_m1w, 18n, 3)
  alter @m.xdut.xmux_s6.m1[l] = agauss(mux_m1l, 18n, 3)
  alter @m.xdut.xmux_s6.m2[w] = agauss(mux_m2w, 18n, 3)
  alter @m.xdut.xmux_s6.m2[l] = agauss(mux_m2l, 18n, 3)
  alter @m.xdut.xmux_s6.m3[w] = agauss(mux_m3w, 18n, 3)
  alter @m.xdut.xmux_s6.m3[l] = agauss(mux_m3l, 18n, 3)
  alter @m.xdut.xmux_s6.m4[w] = agauss(mux_m4w, 18n, 3)
  alter @m.xdut.xmux_s6.m4[l] = agauss(mux_m4l, 18n, 3)
  alter @m.xdut.xmux_s6.m5[w] = agauss(mux_m5w, 18n, 3)
  alter @m.xdut.xmux_s6.m5[l] = agauss(mux_m5l, 18n, 3)
  alter @m.xdut.xmux_s6.m6[w] = agauss(mux_m6w, 18n, 3)
  alter @m.xdut.xmux_s6.m6[l] = agauss(mux_m6l, 18n, 3)
  alter @m.xdut.xmux_s6.m7[w] = agauss(mux_m7w, 18n, 3)
  alter @m.xdut.xmux_s6.m7[l] = agauss(mux_m7l, 18n, 3)
  alter @m.xdut.xmux_s6.m8[w] = agauss(mux_m8w, 18n, 3)
  alter @m.xdut.xmux_s6.m8[l] = agauss(mux_m8l, 18n, 3)
  alter @m.xdut.xmux_s6.m9[w] = agauss(mux_m9w, 18n, 3)
  alter @m.xdut.xmux_s6.m9[l] = agauss(mux_m9l, 18n, 3)
  alter @m.xdut.xmux_s7.mo0[w] = agauss(mux_mo0w, 18n, 3)
  alter @m.xdut.xmux_s7.mo0[l] = agauss(mux_mo0l, 18n, 3)
  alter @m.xdut.xmux_s7.mo1[w] = agauss(mux_mo1w, 18n, 3)
  alter @m.xdut.xmux_s7.mo1[l] = agauss(mux_mo1l, 18n, 3)
  alter @m.xdut.xmux_s7.m0[w] = agauss(mux_m0w, 18n, 3)
  alter @m.xdut.xmux_s7.m0[l] = agauss(mux_m0l, 18n, 3)
  alter @m.xdut.xmux_s7.m1[w] = agauss(mux_m1w, 18n, 3)
  alter @m.xdut.xmux_s7.m1[l] = agauss(mux_m1l, 18n, 3)
  alter @m.xdut.xmux_s7.m2[w] = agauss(mux_m2w, 18n, 3)
  alter @m.xdut.xmux_s7.m2[l] = agauss(mux_m2l, 18n, 3)
  alter @m.xdut.xmux_s7.m3[w] = agauss(mux_m3w, 18n, 3)
  alter @m.xdut.xmux_s7.m3[l] = agauss(mux_m3l, 18n, 3)
  alter @m.xdut.xmux_s7.m4[w] = agauss(mux_m4w, 18n, 3)
  alter @m.xdut.xmux_s7.m4[l] = agauss(mux_m4l, 18n, 3)
  alter @m.xdut.xmux_s7.m5[w] = agauss(mux_m5w, 18n, 3)
  alter @m.xdut.xmux_s7.m5[l] = agauss(mux_m5l, 18n, 3)
  alter @m.xdut.xmux_s7.m6[w] = agauss(mux_m6w, 18n, 3)
  alter @m.xdut.xmux_s7.m6[l] = agauss(mux_m6l, 18n, 3)
  alter @m.xdut.xmux_s7.m7[w] = agauss(mux_m7w, 18n, 3)
  alter @m.xdut.xmux_s7.m7[l] = agauss(mux_m7l, 18n, 3)
  alter @m.xdut.xmux_s7.m8[w] = agauss(mux_m8w, 18n, 3)
  alter @m.xdut.xmux_s7.m8[l] = agauss(mux_m8l, 18n, 3)
  alter @m.xdut.xmux_s7.m9[w] = agauss(mux_m9w, 18n, 3)
  alter @m.xdut.xmux_s7.m9[l] = agauss(mux_m9l, 18n, 3)
  alter @m.xdut.xmux_s8.mo0[w] = agauss(mux_mo0w, 18n, 3)
  alter @m.xdut.xmux_s8.mo0[l] = agauss(mux_mo0l, 18n, 3)
  alter @m.xdut.xmux_s8.mo1[w] = agauss(mux_mo1w, 18n, 3)
  alter @m.xdut.xmux_s8.mo1[l] = agauss(mux_mo1l, 18n, 3)
  alter @m.xdut.xmux_s8.m0[w] = agauss(mux_m0w, 18n, 3)
  alter @m.xdut.xmux_s8.m0[l] = agauss(mux_m0l, 18n, 3)
  alter @m.xdut.xmux_s8.m1[w] = agauss(mux_m1w, 18n, 3)
  alter @m.xdut.xmux_s8.m1[l] = agauss(mux_m1l, 18n, 3)
  alter @m.xdut.xmux_s8.m2[w] = agauss(mux_m2w, 18n, 3)
  alter @m.xdut.xmux_s8.m2[l] = agauss(mux_m2l, 18n, 3)
  alter @m.xdut.xmux_s8.m3[w] = agauss(mux_m3w, 18n, 3)
  alter @m.xdut.xmux_s8.m3[l] = agauss(mux_m3l, 18n, 3)
  alter @m.xdut.xmux_s8.m4[w] = agauss(mux_m4w, 18n, 3)
  alter @m.xdut.xmux_s8.m4[l] = agauss(mux_m4l, 18n, 3)
  alter @m.xdut.xmux_s8.m5[w] = agauss(mux_m5w, 18n, 3)
  alter @m.xdut.xmux_s8.m5[l] = agauss(mux_m5l, 18n, 3)
  alter @m.xdut.xmux_s8.m6[w] = agauss(mux_m6w, 18n, 3)
  alter @m.xdut.xmux_s8.m6[l] = agauss(mux_m6l, 18n, 3)
  alter @m.xdut.xmux_s8.m7[w] = agauss(mux_m7w, 18n, 3)
  alter @m.xdut.xmux_s8.m7[l] = agauss(mux_m7l, 18n, 3)
  alter @m.xdut.xmux_s8.m8[w] = agauss(mux_m8w, 18n, 3)
  alter @m.xdut.xmux_s8.m8[l] = agauss(mux_m8l, 18n, 3)
  alter @m.xdut.xmux_s8.m9[w] = agauss(mux_m9w, 18n, 3)
  alter @m.xdut.xmux_s8.m9[l] = agauss(mux_m9l, 18n, 3)
  alter @m.xdut.xmux_s9.mo0[w] = agauss(mux_mo0w, 18n, 3)
  alter @m.xdut.xmux_s9.mo0[l] = agauss(mux_mo0l, 18n, 3)
  alter @m.xdut.xmux_s9.mo1[w] = agauss(mux_mo1w, 18n, 3)
  alter @m.xdut.xmux_s9.mo1[l] = agauss(mux_mo1l, 18n, 3)
  alter @m.xdut.xmux_s9.m0[w] = agauss(mux_m0w, 18n, 3)
  alter @m.xdut.xmux_s9.m0[l] = agauss(mux_m0l, 18n, 3)
  alter @m.xdut.xmux_s9.m1[w] = agauss(mux_m1w, 18n, 3)
  alter @m.xdut.xmux_s9.m1[l] = agauss(mux_m1l, 18n, 3)
  alter @m.xdut.xmux_s9.m2[w] = agauss(mux_m2w, 18n, 3)
  alter @m.xdut.xmux_s9.m2[l] = agauss(mux_m2l, 18n, 3)
  alter @m.xdut.xmux_s9.m3[w] = agauss(mux_m3w, 18n, 3)
  alter @m.xdut.xmux_s9.m3[l] = agauss(mux_m3l, 18n, 3)
  alter @m.xdut.xmux_s9.m4[w] = agauss(mux_m4w, 18n, 3)
  alter @m.xdut.xmux_s9.m4[l] = agauss(mux_m4l, 18n, 3)
  alter @m.xdut.xmux_s9.m5[w] = agauss(mux_m5w, 18n, 3)
  alter @m.xdut.xmux_s9.m5[l] = agauss(mux_m5l, 18n, 3)
  alter @m.xdut.xmux_s9.m6[w] = agauss(mux_m6w, 18n, 3)
  alter @m.xdut.xmux_s9.m6[l] = agauss(mux_m6l, 18n, 3)
  alter @m.xdut.xmux_s9.m7[w] = agauss(mux_m7w, 18n, 3)
  alter @m.xdut.xmux_s9.m7[l] = agauss(mux_m7l, 18n, 3)
  alter @m.xdut.xmux_s9.m8[w] = agauss(mux_m8w, 18n, 3)
  alter @m.xdut.xmux_s9.m8[l] = agauss(mux_m8l, 18n, 3)
  alter @m.xdut.xmux_s9.m9[w] = agauss(mux_m9w, 18n, 3)
  alter @m.xdut.xmux_s9.m9[l] = agauss(mux_m9l, 18n, 3)
  alter @m.xdut.xmux_sa.mo0[w] = agauss(mux_mo0w, 18n, 3)
  alter @m.xdut.xmux_sa.mo0[l] = agauss(mux_mo0l, 18n, 3)
  alter @m.xdut.xmux_sa.mo1[w] = agauss(mux_mo1w, 18n, 3)
  alter @m.xdut.xmux_sa.mo1[l] = agauss(mux_mo1l, 18n, 3)
  alter @m.xdut.xmux_sa.m0[w] = agauss(mux_m0w, 18n, 3)
  alter @m.xdut.xmux_sa.m0[l] = agauss(mux_m0l, 18n, 3)
  alter @m.xdut.xmux_sa.m1[w] = agauss(mux_m1w, 18n, 3)
  alter @m.xdut.xmux_sa.m1[l] = agauss(mux_m1l, 18n, 3)
  alter @m.xdut.xmux_sa.m2[w] = agauss(mux_m2w, 18n, 3)
  alter @m.xdut.xmux_sa.m2[l] = agauss(mux_m2l, 18n, 3)
  alter @m.xdut.xmux_sa.m3[w] = agauss(mux_m3w, 18n, 3)
  alter @m.xdut.xmux_sa.m3[l] = agauss(mux_m3l, 18n, 3)
  alter @m.xdut.xmux_sa.m4[w] = agauss(mux_m4w, 18n, 3)
  alter @m.xdut.xmux_sa.m4[l] = agauss(mux_m4l, 18n, 3)
  alter @m.xdut.xmux_sa.m5[w] = agauss(mux_m5w, 18n, 3)
  alter @m.xdut.xmux_sa.m5[l] = agauss(mux_m5l, 18n, 3)
  alter @m.xdut.xmux_sa.m6[w] = agauss(mux_m6w, 18n, 3)
  alter @m.xdut.xmux_sa.m6[l] = agauss(mux_m6l, 18n, 3)
  alter @m.xdut.xmux_sa.m7[w] = agauss(mux_m7w, 18n, 3)
  alter @m.xdut.xmux_sa.m7[l] = agauss(mux_m7l, 18n, 3)
  alter @m.xdut.xmux_sa.m8[w] = agauss(mux_m8w, 18n, 3)
  alter @m.xdut.xmux_sa.m8[l] = agauss(mux_m8l, 18n, 3)
  alter @m.xdut.xmux_sa.m9[w] = agauss(mux_m9w, 18n, 3)
  alter @m.xdut.xmux_sa.m9[l] = agauss(mux_m9l, 18n, 3)
  alter @m.xdut.xmux_sb.mo0[w] = agauss(mux_mo0w, 18n, 3)
  alter @m.xdut.xmux_sb.mo0[l] = agauss(mux_mo0l, 18n, 3)
  alter @m.xdut.xmux_sb.mo1[w] = agauss(mux_mo1w, 18n, 3)
  alter @m.xdut.xmux_sb.mo1[l] = agauss(mux_mo1l, 18n, 3)
  alter @m.xdut.xmux_sb.m0[w] = agauss(mux_m0w, 18n, 3)
  alter @m.xdut.xmux_sb.m0[l] = agauss(mux_m0l, 18n, 3)
  alter @m.xdut.xmux_sb.m1[w] = agauss(mux_m1w, 18n, 3)
  alter @m.xdut.xmux_sb.m1[l] = agauss(mux_m1l, 18n, 3)
  alter @m.xdut.xmux_sb.m2[w] = agauss(mux_m2w, 18n, 3)
  alter @m.xdut.xmux_sb.m2[l] = agauss(mux_m2l, 18n, 3)
  alter @m.xdut.xmux_sb.m3[w] = agauss(mux_m3w, 18n, 3)
  alter @m.xdut.xmux_sb.m3[l] = agauss(mux_m3l, 18n, 3)
  alter @m.xdut.xmux_sb.m4[w] = agauss(mux_m4w, 18n, 3)
  alter @m.xdut.xmux_sb.m4[l] = agauss(mux_m4l, 18n, 3)
  alter @m.xdut.xmux_sb.m5[w] = agauss(mux_m5w, 18n, 3)
  alter @m.xdut.xmux_sb.m5[l] = agauss(mux_m5l, 18n, 3)
  alter @m.xdut.xmux_sb.m6[w] = agauss(mux_m6w, 18n, 3)
  alter @m.xdut.xmux_sb.m6[l] = agauss(mux_m6l, 18n, 3)
  alter @m.xdut.xmux_sb.m7[w] = agauss(mux_m7w, 18n, 3)
  alter @m.xdut.xmux_sb.m7[l] = agauss(mux_m7l, 18n, 3)
  alter @m.xdut.xmux_sb.m8[w] = agauss(mux_m8w, 18n, 3)
  alter @m.xdut.xmux_sb.m8[l] = agauss(mux_m8l, 18n, 3)
  alter @m.xdut.xmux_sb.m9[w] = agauss(mux_m9w, 18n, 3)
  alter @m.xdut.xmux_sb.m9[l] = agauss(mux_m9l, 18n, 3)
  alter @m.xdut.xmux_sc.mo0[w] = agauss(mux_mo0w, 18n, 3)
  alter @m.xdut.xmux_sc.mo0[l] = agauss(mux_mo0l, 18n, 3)
  alter @m.xdut.xmux_sc.mo1[w] = agauss(mux_mo1w, 18n, 3)
  alter @m.xdut.xmux_sc.mo1[l] = agauss(mux_mo1l, 18n, 3)
  alter @m.xdut.xmux_sc.m0[w] = agauss(mux_m0w, 18n, 3)
  alter @m.xdut.xmux_sc.m0[l] = agauss(mux_m0l, 18n, 3)
  alter @m.xdut.xmux_sc.m1[w] = agauss(mux_m1w, 18n, 3)
  alter @m.xdut.xmux_sc.m1[l] = agauss(mux_m1l, 18n, 3)
  alter @m.xdut.xmux_sc.m2[w] = agauss(mux_m2w, 18n, 3)
  alter @m.xdut.xmux_sc.m2[l] = agauss(mux_m2l, 18n, 3)
  alter @m.xdut.xmux_sc.m3[w] = agauss(mux_m3w, 18n, 3)
  alter @m.xdut.xmux_sc.m3[l] = agauss(mux_m3l, 18n, 3)
  alter @m.xdut.xmux_sc.m4[w] = agauss(mux_m4w, 18n, 3)
  alter @m.xdut.xmux_sc.m4[l] = agauss(mux_m4l, 18n, 3)
  alter @m.xdut.xmux_sc.m5[w] = agauss(mux_m5w, 18n, 3)
  alter @m.xdut.xmux_sc.m5[l] = agauss(mux_m5l, 18n, 3)
  alter @m.xdut.xmux_sc.m6[w] = agauss(mux_m6w, 18n, 3)
  alter @m.xdut.xmux_sc.m6[l] = agauss(mux_m6l, 18n, 3)
  alter @m.xdut.xmux_sc.m7[w] = agauss(mux_m7w, 18n, 3)
  alter @m.xdut.xmux_sc.m7[l] = agauss(mux_m7l, 18n, 3)
  alter @m.xdut.xmux_sc.m8[w] = agauss(mux_m8w, 18n, 3)
  alter @m.xdut.xmux_sc.m8[l] = agauss(mux_m8l, 18n, 3)
  alter @m.xdut.xmux_sc.m9[w] = agauss(mux_m9w, 18n, 3)
  alter @m.xdut.xmux_sc.m9[l] = agauss(mux_m9l, 18n, 3)
  alter @m.xdut.xmux_sd.mo0[w] = agauss(mux_mo0w, 18n, 3)
  alter @m.xdut.xmux_sd.mo0[l] = agauss(mux_mo0l, 18n, 3)
  alter @m.xdut.xmux_sd.mo1[w] = agauss(mux_mo1w, 18n, 3)
  alter @m.xdut.xmux_sd.mo1[l] = agauss(mux_mo1l, 18n, 3)
  alter @m.xdut.xmux_sd.m0[w] = agauss(mux_m0w, 18n, 3)
  alter @m.xdut.xmux_sd.m0[l] = agauss(mux_m0l, 18n, 3)
  alter @m.xdut.xmux_sd.m1[w] = agauss(mux_m1w, 18n, 3)
  alter @m.xdut.xmux_sd.m1[l] = agauss(mux_m1l, 18n, 3)
  alter @m.xdut.xmux_sd.m2[w] = agauss(mux_m2w, 18n, 3)
  alter @m.xdut.xmux_sd.m2[l] = agauss(mux_m2l, 18n, 3)
  alter @m.xdut.xmux_sd.m3[w] = agauss(mux_m3w, 18n, 3)
  alter @m.xdut.xmux_sd.m3[l] = agauss(mux_m3l, 18n, 3)
  alter @m.xdut.xmux_sd.m4[w] = agauss(mux_m4w, 18n, 3)
  alter @m.xdut.xmux_sd.m4[l] = agauss(mux_m4l, 18n, 3)
  alter @m.xdut.xmux_sd.m5[w] = agauss(mux_m5w, 18n, 3)
  alter @m.xdut.xmux_sd.m5[l] = agauss(mux_m5l, 18n, 3)
  alter @m.xdut.xmux_sd.m6[w] = agauss(mux_m6w, 18n, 3)
  alter @m.xdut.xmux_sd.m6[l] = agauss(mux_m6l, 18n, 3)
  alter @m.xdut.xmux_sd.m7[w] = agauss(mux_m7w, 18n, 3)
  alter @m.xdut.xmux_sd.m7[l] = agauss(mux_m7l, 18n, 3)
  alter @m.xdut.xmux_sd.m8[w] = agauss(mux_m8w, 18n, 3)
  alter @m.xdut.xmux_sd.m8[l] = agauss(mux_m8l, 18n, 3)
  alter @m.xdut.xmux_sd.m9[w] = agauss(mux_m9w, 18n, 3)
  alter @m.xdut.xmux_sd.m9[l] = agauss(mux_m9l, 18n, 3)
  alter @m.xdut.xmux_se.mo0[w] = agauss(mux_mo0w, 18n, 3)
  alter @m.xdut.xmux_se.mo0[l] = agauss(mux_mo0l, 18n, 3)
  alter @m.xdut.xmux_se.mo1[w] = agauss(mux_mo1w, 18n, 3)
  alter @m.xdut.xmux_se.mo1[l] = agauss(mux_mo1l, 18n, 3)
  alter @m.xdut.xmux_se.m0[w] = agauss(mux_m0w, 18n, 3)
  alter @m.xdut.xmux_se.m0[l] = agauss(mux_m0l, 18n, 3)
  alter @m.xdut.xmux_se.m1[w] = agauss(mux_m1w, 18n, 3)
  alter @m.xdut.xmux_se.m1[l] = agauss(mux_m1l, 18n, 3)
  alter @m.xdut.xmux_se.m2[w] = agauss(mux_m2w, 18n, 3)
  alter @m.xdut.xmux_se.m2[l] = agauss(mux_m2l, 18n, 3)
  alter @m.xdut.xmux_se.m3[w] = agauss(mux_m3w, 18n, 3)
  alter @m.xdut.xmux_se.m3[l] = agauss(mux_m3l, 18n, 3)
  alter @m.xdut.xmux_se.m4[w] = agauss(mux_m4w, 18n, 3)
  alter @m.xdut.xmux_se.m4[l] = agauss(mux_m4l, 18n, 3)
  alter @m.xdut.xmux_se.m5[w] = agauss(mux_m5w, 18n, 3)
  alter @m.xdut.xmux_se.m5[l] = agauss(mux_m5l, 18n, 3)
  alter @m.xdut.xmux_se.m6[w] = agauss(mux_m6w, 18n, 3)
  alter @m.xdut.xmux_se.m6[l] = agauss(mux_m6l, 18n, 3)
  alter @m.xdut.xmux_se.m7[w] = agauss(mux_m7w, 18n, 3)
  alter @m.xdut.xmux_se.m7[l] = agauss(mux_m7l, 18n, 3)
  alter @m.xdut.xmux_se.m8[w] = agauss(mux_m8w, 18n, 3)
  alter @m.xdut.xmux_se.m8[l] = agauss(mux_m8l, 18n, 3)
  alter @m.xdut.xmux_se.m9[w] = agauss(mux_m9w, 18n, 3)
  alter @m.xdut.xmux_se.m9[l] = agauss(mux_m9l, 18n, 3)
  alter @m.xdut.xmux_sf.mo0[w] = agauss(mux_mo0w, 18n, 3)
  alter @m.xdut.xmux_sf.mo0[l] = agauss(mux_mo0l, 18n, 3)
  alter @m.xdut.xmux_sf.mo1[w] = agauss(mux_mo1w, 18n, 3)
  alter @m.xdut.xmux_sf.mo1[l] = agauss(mux_mo1l, 18n, 3)
  alter @m.xdut.xmux_sf.m0[w] = agauss(mux_m0w, 18n, 3)
  alter @m.xdut.xmux_sf.m0[l] = agauss(mux_m0l, 18n, 3)
  alter @m.xdut.xmux_sf.m1[w] = agauss(mux_m1w, 18n, 3)
  alter @m.xdut.xmux_sf.m1[l] = agauss(mux_m1l, 18n, 3)
  alter @m.xdut.xmux_sf.m2[w] = agauss(mux_m2w, 18n, 3)
  alter @m.xdut.xmux_sf.m2[l] = agauss(mux_m2l, 18n, 3)
  alter @m.xdut.xmux_sf.m3[w] = agauss(mux_m3w, 18n, 3)
  alter @m.xdut.xmux_sf.m3[l] = agauss(mux_m3l, 18n, 3)
  alter @m.xdut.xmux_sf.m4[w] = agauss(mux_m4w, 18n, 3)
  alter @m.xdut.xmux_sf.m4[l] = agauss(mux_m4l, 18n, 3)
  alter @m.xdut.xmux_sf.m5[w] = agauss(mux_m5w, 18n, 3)
  alter @m.xdut.xmux_sf.m5[l] = agauss(mux_m5l, 18n, 3)
  alter @m.xdut.xmux_sf.m6[w] = agauss(mux_m6w, 18n, 3)
  alter @m.xdut.xmux_sf.m6[l] = agauss(mux_m6l, 18n, 3)
  alter @m.xdut.xmux_sf.m7[w] = agauss(mux_m7w, 18n, 3)
  alter @m.xdut.xmux_sf.m7[l] = agauss(mux_m7l, 18n, 3)
  alter @m.xdut.xmux_sf.m8[w] = agauss(mux_m8w, 18n, 3)
  alter @m.xdut.xmux_sf.m8[l] = agauss(mux_m8l, 18n, 3)
  alter @m.xdut.xmux_sf.m9[w] = agauss(mux_m9w, 18n, 3)
  alter @m.xdut.xmux_sf.m9[l] = agauss(mux_m9l, 18n, 3)
  alter @m.xdut.xmux_c2.mo0[w] = agauss(mux_mo0w, 18n, 3)
  alter @m.xdut.xmux_c2.mo0[l] = agauss(mux_mo0l, 18n, 3)
  alter @m.xdut.xmux_c2.mo1[w] = agauss(mux_mo1w, 18n, 3)
  alter @m.xdut.xmux_c2.mo1[l] = agauss(mux_mo1l, 18n, 3)
  alter @m.xdut.xmux_c2.m0[w] = agauss(mux_m0w, 18n, 3)
  alter @m.xdut.xmux_c2.m0[l] = agauss(mux_m0l, 18n, 3)
  alter @m.xdut.xmux_c2.m1[w] = agauss(mux_m1w, 18n, 3)
  alter @m.xdut.xmux_c2.m1[l] = agauss(mux_m1l, 18n, 3)
  alter @m.xdut.xmux_c2.m2[w] = agauss(mux_m2w, 18n, 3)
  alter @m.xdut.xmux_c2.m2[l] = agauss(mux_m2l, 18n, 3)
  alter @m.xdut.xmux_c2.m3[w] = agauss(mux_m3w, 18n, 3)
  alter @m.xdut.xmux_c2.m3[l] = agauss(mux_m3l, 18n, 3)
  alter @m.xdut.xmux_c2.m4[w] = agauss(mux_m4w, 18n, 3)
  alter @m.xdut.xmux_c2.m4[l] = agauss(mux_m4l, 18n, 3)
  alter @m.xdut.xmux_c2.m5[w] = agauss(mux_m5w, 18n, 3)
  alter @m.xdut.xmux_c2.m5[l] = agauss(mux_m5l, 18n, 3)
  alter @m.xdut.xmux_c2.m6[w] = agauss(mux_m6w, 18n, 3)
  alter @m.xdut.xmux_c2.m6[l] = agauss(mux_m6l, 18n, 3)
  alter @m.xdut.xmux_c2.m7[w] = agauss(mux_m7w, 18n, 3)
  alter @m.xdut.xmux_c2.m7[l] = agauss(mux_m7l, 18n, 3)
  alter @m.xdut.xmux_c2.m8[w] = agauss(mux_m8w, 18n, 3)
  alter @m.xdut.xmux_c2.m8[l] = agauss(mux_m8l, 18n, 3)
  alter @m.xdut.xmux_c2.m9[w] = agauss(mux_m9w, 18n, 3)
  alter @m.xdut.xmux_c2.m9[l] = agauss(mux_m9l, 18n, 3)
  alter @m.xdut.xmux_c5.mo0[w] = agauss(mux_mo0w, 18n, 3)
  alter @m.xdut.xmux_c5.mo0[l] = agauss(mux_mo0l, 18n, 3)
  alter @m.xdut.xmux_c5.mo1[w] = agauss(mux_mo1w, 18n, 3)
  alter @m.xdut.xmux_c5.mo1[l] = agauss(mux_mo1l, 18n, 3)
  alter @m.xdut.xmux_c5.m0[w] = agauss(mux_m0w, 18n, 3)
  alter @m.xdut.xmux_c5.m0[l] = agauss(mux_m0l, 18n, 3)
  alter @m.xdut.xmux_c5.m1[w] = agauss(mux_m1w, 18n, 3)
  alter @m.xdut.xmux_c5.m1[l] = agauss(mux_m1l, 18n, 3)
  alter @m.xdut.xmux_c5.m2[w] = agauss(mux_m2w, 18n, 3)
  alter @m.xdut.xmux_c5.m2[l] = agauss(mux_m2l, 18n, 3)
  alter @m.xdut.xmux_c5.m3[w] = agauss(mux_m3w, 18n, 3)
  alter @m.xdut.xmux_c5.m3[l] = agauss(mux_m3l, 18n, 3)
  alter @m.xdut.xmux_c5.m4[w] = agauss(mux_m4w, 18n, 3)
  alter @m.xdut.xmux_c5.m4[l] = agauss(mux_m4l, 18n, 3)
  alter @m.xdut.xmux_c5.m5[w] = agauss(mux_m5w, 18n, 3)
  alter @m.xdut.xmux_c5.m5[l] = agauss(mux_m5l, 18n, 3)
  alter @m.xdut.xmux_c5.m6[w] = agauss(mux_m6w, 18n, 3)
  alter @m.xdut.xmux_c5.m6[l] = agauss(mux_m6l, 18n, 3)
  alter @m.xdut.xmux_c5.m7[w] = agauss(mux_m7w, 18n, 3)
  alter @m.xdut.xmux_c5.m7[l] = agauss(mux_m7l, 18n, 3)
  alter @m.xdut.xmux_c5.m8[w] = agauss(mux_m8w, 18n, 3)
  alter @m.xdut.xmux_c5.m8[l] = agauss(mux_m8l, 18n, 3)
  alter @m.xdut.xmux_c5.m9[w] = agauss(mux_m9w, 18n, 3)
  alter @m.xdut.xmux_c5.m9[l] = agauss(mux_m9l, 18n, 3)
  alter @m.xdut.xmux_c9.mo0[w] = agauss(mux_mo0w, 18n, 3)
  alter @m.xdut.xmux_c9.mo0[l] = agauss(mux_mo0l, 18n, 3)
  alter @m.xdut.xmux_c9.mo1[w] = agauss(mux_mo1w, 18n, 3)
  alter @m.xdut.xmux_c9.mo1[l] = agauss(mux_mo1l, 18n, 3)
  alter @m.xdut.xmux_c9.m0[w] = agauss(mux_m0w, 18n, 3)
  alter @m.xdut.xmux_c9.m0[l] = agauss(mux_m0l, 18n, 3)
  alter @m.xdut.xmux_c9.m1[w] = agauss(mux_m1w, 18n, 3)
  alter @m.xdut.xmux_c9.m1[l] = agauss(mux_m1l, 18n, 3)
  alter @m.xdut.xmux_c9.m2[w] = agauss(mux_m2w, 18n, 3)
  alter @m.xdut.xmux_c9.m2[l] = agauss(mux_m2l, 18n, 3)
  alter @m.xdut.xmux_c9.m3[w] = agauss(mux_m3w, 18n, 3)
  alter @m.xdut.xmux_c9.m3[l] = agauss(mux_m3l, 18n, 3)
  alter @m.xdut.xmux_c9.m4[w] = agauss(mux_m4w, 18n, 3)
  alter @m.xdut.xmux_c9.m4[l] = agauss(mux_m4l, 18n, 3)
  alter @m.xdut.xmux_c9.m5[w] = agauss(mux_m5w, 18n, 3)
  alter @m.xdut.xmux_c9.m5[l] = agauss(mux_m5l, 18n, 3)
  alter @m.xdut.xmux_c9.m6[w] = agauss(mux_m6w, 18n, 3)
  alter @m.xdut.xmux_c9.m6[l] = agauss(mux_m6l, 18n, 3)
  alter @m.xdut.xmux_c9.m7[w] = agauss(mux_m7w, 18n, 3)
  alter @m.xdut.xmux_c9.m7[l] = agauss(mux_m7l, 18n, 3)
  alter @m.xdut.xmux_c9.m8[w] = agauss(mux_m8w, 18n, 3)
  alter @m.xdut.xmux_c9.m8[l] = agauss(mux_m8l, 18n, 3)
  alter @m.xdut.xmux_c9.m9[w] = agauss(mux_m9w, 18n, 3)
  alter @m.xdut.xmux_c9.m9[l] = agauss(mux_m9l, 18n, 3)
  alter @m.xdut.xmux_ce.mo0[w] = agauss(mux_mo0w, 18n, 3)
  alter @m.xdut.xmux_ce.mo0[l] = agauss(mux_mo0l, 18n, 3)
  alter @m.xdut.xmux_ce.mo1[w] = agauss(mux_mo1w, 18n, 3)
  alter @m.xdut.xmux_ce.mo1[l] = agauss(mux_mo1l, 18n, 3)
  alter @m.xdut.xmux_ce.m0[w] = agauss(mux_m0w, 18n, 3)
  alter @m.xdut.xmux_ce.m0[l] = agauss(mux_m0l, 18n, 3)
  alter @m.xdut.xmux_ce.m1[w] = agauss(mux_m1w, 18n, 3)
  alter @m.xdut.xmux_ce.m1[l] = agauss(mux_m1l, 18n, 3)
  alter @m.xdut.xmux_ce.m2[w] = agauss(mux_m2w, 18n, 3)
  alter @m.xdut.xmux_ce.m2[l] = agauss(mux_m2l, 18n, 3)
  alter @m.xdut.xmux_ce.m3[w] = agauss(mux_m3w, 18n, 3)
  alter @m.xdut.xmux_ce.m3[l] = agauss(mux_m3l, 18n, 3)
  alter @m.xdut.xmux_ce.m4[w] = agauss(mux_m4w, 18n, 3)
  alter @m.xdut.xmux_ce.m4[l] = agauss(mux_m4l, 18n, 3)
  alter @m.xdut.xmux_ce.m5[w] = agauss(mux_m5w, 18n, 3)
  alter @m.xdut.xmux_ce.m5[l] = agauss(mux_m5l, 18n, 3)
  alter @m.xdut.xmux_ce.m6[w] = agauss(mux_m6w, 18n, 3)
  alter @m.xdut.xmux_ce.m6[l] = agauss(mux_m6l, 18n, 3)
  alter @m.xdut.xmux_ce.m7[w] = agauss(mux_m7w, 18n, 3)
  alter @m.xdut.xmux_ce.m7[l] = agauss(mux_m7l, 18n, 3)
  alter @m.xdut.xmux_ce.m8[w] = agauss(mux_m8w, 18n, 3)
  alter @m.xdut.xmux_ce.m8[l] = agauss(mux_m8l, 18n, 3)
  alter @m.xdut.xmux_ce.m9[w] = agauss(mux_m9w, 18n, 3)
  alter @m.xdut.xmux_ce.m9[l] = agauss(mux_m9l, 18n, 3)
  alter @m.xdut.xmux_cout.mo0[w] = agauss(mux_mo0w, 18n, 3)
  alter @m.xdut.xmux_cout.mo0[l] = agauss(mux_mo0l, 18n, 3)
  alter @m.xdut.xmux_cout.mo1[w] = agauss(mux_mo1w, 18n, 3)
  alter @m.xdut.xmux_cout.mo1[l] = agauss(mux_mo1l, 18n, 3)
  alter @m.xdut.xmux_cout.m0[w] = agauss(mux_m0w, 18n, 3)
  alter @m.xdut.xmux_cout.m0[l] = agauss(mux_m0l, 18n, 3)
  alter @m.xdut.xmux_cout.m1[w] = agauss(mux_m1w, 18n, 3)
  alter @m.xdut.xmux_cout.m1[l] = agauss(mux_m1l, 18n, 3)
  alter @m.xdut.xmux_cout.m2[w] = agauss(mux_m2w, 18n, 3)
  alter @m.xdut.xmux_cout.m2[l] = agauss(mux_m2l, 18n, 3)
  alter @m.xdut.xmux_cout.m3[w] = agauss(mux_m3w, 18n, 3)
  alter @m.xdut.xmux_cout.m3[l] = agauss(mux_m3l, 18n, 3)
  alter @m.xdut.xmux_cout.m4[w] = agauss(mux_m4w, 18n, 3)
  alter @m.xdut.xmux_cout.m4[l] = agauss(mux_m4l, 18n, 3)
  alter @m.xdut.xmux_cout.m5[w] = agauss(mux_m5w, 18n, 3)
  alter @m.xdut.xmux_cout.m5[l] = agauss(mux_m5l, 18n, 3)
  alter @m.xdut.xmux_cout.m6[w] = agauss(mux_m6w, 18n, 3)
  alter @m.xdut.xmux_cout.m6[l] = agauss(mux_m6l, 18n, 3)
  alter @m.xdut.xmux_cout.m7[w] = agauss(mux_m7w, 18n, 3)
  alter @m.xdut.xmux_cout.m7[l] = agauss(mux_m7l, 18n, 3)
  alter @m.xdut.xmux_cout.m8[w] = agauss(mux_m8w, 18n, 3)
  alter @m.xdut.xmux_cout.m8[l] = agauss(mux_m8l, 18n, 3)
  alter @m.xdut.xmux_cout.m9[w] = agauss(mux_m9w, 18n, 3)
  alter @m.xdut.xmux_cout.m9[l] = agauss(mux_m9l, 18n, 3)

  tran 10p 150n 40n
  meas tran d_lh_cout TRIG v(b0) val=1.65 rise=1 TARG v(cout) val=1.65 rise=1
  meas tran d_hl_cout TRIG v(b0) val=1.65 fall=1 TARG v(cout) val=1.65 fall=1
  meas tran d_hl_sf   TRIG v(b0) val=1.65 rise=1 TARG v(sf)   val=1.65 fall=1
  meas tran d_lh_sf   TRIG v(b0) val=1.65 fall=1 TARG v(sf)   val=1.65 rise=1

  set simplot = $curplot
  setplot $tran_meas

  let tplh_cout[current_run] = {$simplot}.d_lh_cout
  let tphl_cout[current_run] = {$simplot}.d_hl_cout
  let tplh_sf[current_run]   = {$simplot}.d_lh_sf
  let tphl_sf[current_run]   = {$simplot}.d_hl_sf

  destroy $simplot
  let current_run = current_run + 1
end

print tplh_cout tphl_cout tplh_sf tphl_sf

set wr_singlescale
set wr_vecnames
wrdata carry_select_mc.txt tplh_cout tphl_cout tplh_sf tphl_sf
quit
.endc
.end
